* SPICE3 file created from counter.ext - technology: sky130A

.option scale=5m

X0 sky130_fd_sc_hd__ha_1_0/a_297_47# sky130_fd_sc_hd__ha_1_0/a_250_199# sky130_fd_sc_hd__ha_1_0/a_79_21# SUB sky130_fd_pr__nfet_01v8 ad=2.268n pd=0.138m as=4.368n ps=0.272m w=84 l=30
X1 sky130_fd_sc_hd__ha_1_0/a_297_47# sky130_fd_sc_hd__ha_1_0/A SUB SUB sky130_fd_pr__nfet_01v8 ad=4.368n pd=0.272m as=2.268n ps=0.138m w=84 l=30
X2 sky130_fd_sc_hd__xor2_1_2/B sky130_fd_sc_hd__ha_1_0/a_250_199# SUB SUB sky130_fd_pr__pfet_01v8_hvt ad=10.4n pd=0.504m as=5.63n ps=0.265m w=200 l=30
X3 sky130_fd_sc_hd__ha_1_0/a_250_199# sky130_fd_sc_hd__ha_1_0/B SUB SUB sky130_fd_pr__pfet_01v8_hvt ad=2.436n pd=0.142m as=5.964n ps=0.226m w=84 l=30
X4 sky130_fd_sc_hd__ha_1_0/a_376_413# sky130_fd_sc_hd__ha_1_0/B sky130_fd_sc_hd__ha_1_0/a_79_21# SUB sky130_fd_pr__pfet_01v8_hvt ad=3.36n pd=0.164m as=2.268n ps=0.138m w=84 l=30
X5 sky130_fd_sc_hd__ha_1_0/a_79_21# sky130_fd_sc_hd__ha_1_0/a_250_199# SUB SUB sky130_fd_pr__pfet_01v8_hvt ad=2.268n pd=0.138m as=9.442n ps=0.353m w=84 l=30
X6 sky130_fd_sc_hd__ha_1_0/a_674_47# sky130_fd_sc_hd__ha_1_0/B sky130_fd_sc_hd__ha_1_0/a_250_199# SUB sky130_fd_pr__nfet_01v8 ad=1.764n pd=0.126m as=4.368n ps=0.272m w=84 l=30
X7 SUB sky130_fd_sc_hd__ha_1_0/A sky130_fd_sc_hd__ha_1_0/a_376_413# SUB sky130_fd_pr__pfet_01v8_hvt ad=5.964n pd=0.226m as=3.36n ps=0.164m w=84 l=30
X8 SUB sky130_fd_sc_hd__ha_1_0/B sky130_fd_sc_hd__ha_1_0/a_297_47# SUB sky130_fd_pr__nfet_01v8 ad=2.268n pd=0.138m as=2.268n ps=0.138m w=84 l=30
X9 sky130_fd_sc_hd__xor2_1_2/B sky130_fd_sc_hd__ha_1_0/a_250_199# SUB SUB sky130_fd_pr__nfet_01v8 ad=6.76n pd=0.364m as=3.88n ps=0.195m w=130 l=30
X10 SUB sky130_fd_sc_hd__ha_1_0/a_79_21# sky130_fd_sc_hd__ha_1_0/SUM SUB sky130_fd_pr__pfet_01v8_hvt ad=9.442n pd=0.353m as=10.4n ps=0.504m w=200 l=30
X11 SUB sky130_fd_sc_hd__ha_1_0/A sky130_fd_sc_hd__ha_1_0/a_250_199# SUB sky130_fd_pr__pfet_01v8_hvt ad=5.63n pd=0.265m as=2.436n ps=0.142m w=84 l=30
X12 SUB sky130_fd_sc_hd__ha_1_0/A sky130_fd_sc_hd__ha_1_0/a_674_47# SUB sky130_fd_pr__nfet_01v8 ad=3.88n pd=0.195m as=1.764n ps=0.126m w=84 l=30
X13 SUB sky130_fd_sc_hd__ha_1_0/a_79_21# sky130_fd_sc_hd__ha_1_0/SUM SUB sky130_fd_pr__nfet_01v8 ad=6.76n pd=0.364m as=6.76n ps=0.364m w=130 l=30
X14 sky130_fd_sc_hd__dfrtp_1_0/a_1217_47# sky130_fd_sc_hd__dfrtp_1_0/a_27_47# sky130_fd_sc_hd__dfrtp_1_0/a_1108_47# SUB sky130_fd_pr__nfet_01v8 ad=2.676n pd=0.15m as=2.844n ps=0.151m w=72 l=30
X15 sky130_fd_sc_hd__dfrtp_1_0/a_805_47# sky130_fd_sc_hd__dfrtp_1_0/a_761_289# sky130_fd_sc_hd__dfrtp_1_0/a_639_47# SUB sky130_fd_pr__nfet_01v8 ad=1.764n pd=0.126m as=5.604n ps=0.22m w=84 l=30
X16 sky130_fd_sc_hd__dfrtp_1_0/a_1108_47# sky130_fd_sc_hd__dfrtp_1_0/a_193_47# sky130_fd_sc_hd__dfrtp_1_0/a_761_289# SUB sky130_fd_pr__nfet_01v8 ad=2.844n pd=0.151m as=3.996n ps=0.197m w=72 l=30
X17 sky130_fd_sc_hd__dfrtp_1_0/a_1283_21# sky130_fd_sc_hd__dfrtp_1_0/a_1108_47# sky130_fd_sc_hd__dfrtp_1_0/a_1462_47# SUB sky130_fd_pr__nfet_01v8 ad=4.368n pd=0.272m as=2.562n ps=0.145m w=84 l=30
X18 sky130_fd_sc_hd__dfrtp_1_0/a_651_413# sky130_fd_sc_hd__dfrtp_1_0/a_27_47# sky130_fd_sc_hd__dfrtp_1_0/a_543_47# SUB sky130_fd_pr__pfet_01v8_hvt ad=4.62n pd=0.194m as=2.898n ps=0.153m w=84 l=30
X19 SUB sky130_fd_sc_hd__inv_2_0/Y sky130_fd_sc_hd__dfrtp_1_0/a_805_47# SUB sky130_fd_pr__nfet_01v8 ad=5.384n pd=0.23m as=1.764n ps=0.126m w=84 l=30
X20 sky130_fd_sc_hd__buf_4_0/A sky130_fd_sc_hd__dfrtp_1_0/a_1283_21# SUB SUB sky130_fd_pr__pfet_01v8_hvt ad=10.4n pd=0.504m as=12.048n ps=0.532m w=200 l=30
X21 SUB sky130_fd_sc_hd__clkbuf_2_1/X sky130_fd_sc_hd__dfrtp_1_0/a_27_47# SUB sky130_fd_pr__pfet_01v8_hvt ad=3.456n pd=0.182m as=6.656n ps=0.36m w=128 l=30
X22 sky130_fd_sc_hd__dfrtp_1_0/a_448_47# sky130_fd_sc_hd__xor2_1_0/X SUB SUB sky130_fd_pr__pfet_01v8_hvt ad=2.604n pd=0.146m as=4.368n ps=0.272m w=84 l=30
X23 sky130_fd_sc_hd__dfrtp_1_0/a_761_289# sky130_fd_sc_hd__dfrtp_1_0/a_543_47# SUB SUB sky130_fd_pr__nfet_01v8 ad=3.996n pd=0.197m as=5.384n ps=0.23m w=128 l=30
X24 sky130_fd_sc_hd__dfrtp_1_0/a_193_47# sky130_fd_sc_hd__dfrtp_1_0/a_27_47# SUB SUB sky130_fd_pr__nfet_01v8 ad=4.368n pd=0.272m as=2.268n ps=0.138m w=84 l=30
X25 sky130_fd_sc_hd__dfrtp_1_0/a_1108_47# sky130_fd_sc_hd__dfrtp_1_0/a_27_47# sky130_fd_sc_hd__dfrtp_1_0/a_761_289# SUB sky130_fd_pr__pfet_01v8_hvt ad=2.352n pd=0.14m as=5.166n ps=0.237m w=84 l=30
X26 sky130_fd_sc_hd__dfrtp_1_0/a_543_47# sky130_fd_sc_hd__dfrtp_1_0/a_27_47# sky130_fd_sc_hd__dfrtp_1_0/a_448_47# SUB sky130_fd_pr__nfet_01v8 ad=2.376n pd=0.138m as=2.64n ps=0.149m w=72 l=30
X27 sky130_fd_sc_hd__dfrtp_1_0/a_1462_47# sky130_fd_sc_hd__inv_2_0/Y SUB SUB sky130_fd_pr__nfet_01v8 ad=2.562n pd=0.145m as=4.998n ps=0.203m w=84 l=30
X28 sky130_fd_sc_hd__dfrtp_1_0/a_543_47# sky130_fd_sc_hd__dfrtp_1_0/a_193_47# sky130_fd_sc_hd__dfrtp_1_0/a_448_47# SUB sky130_fd_pr__pfet_01v8_hvt ad=2.898n pd=0.153m as=2.604n ps=0.146m w=84 l=30
X29 sky130_fd_sc_hd__dfrtp_1_0/a_448_47# sky130_fd_sc_hd__xor2_1_0/X SUB SUB sky130_fd_pr__nfet_01v8 ad=2.64n pd=0.149m as=8.82n ps=0.378m w=84 l=30
X30 SUB sky130_fd_sc_hd__dfrtp_1_0/a_1283_21# sky130_fd_sc_hd__dfrtp_1_0/a_1270_413# SUB sky130_fd_pr__pfet_01v8_hvt ad=3.276n pd=0.162m as=2.268n ps=0.138m w=84 l=30
X31 SUB sky130_fd_sc_hd__dfrtp_1_0/a_1108_47# sky130_fd_sc_hd__dfrtp_1_0/a_1283_21# SUB sky130_fd_pr__pfet_01v8_hvt ad=4.536n pd=0.276m as=2.268n ps=0.138m w=84 l=30
X32 sky130_fd_sc_hd__dfrtp_1_0/a_1270_413# sky130_fd_sc_hd__dfrtp_1_0/a_193_47# sky130_fd_sc_hd__dfrtp_1_0/a_1108_47# SUB sky130_fd_pr__pfet_01v8_hvt ad=2.268n pd=0.138m as=2.352n ps=0.14m w=84 l=30
X33 sky130_fd_sc_hd__dfrtp_1_0/a_193_47# sky130_fd_sc_hd__dfrtp_1_0/a_27_47# SUB SUB sky130_fd_pr__pfet_01v8_hvt ad=6.656n pd=0.36m as=3.456n ps=0.182m w=128 l=30
X34 sky130_fd_sc_hd__dfrtp_1_0/a_1283_21# sky130_fd_sc_hd__inv_2_0/Y SUB SUB sky130_fd_pr__pfet_01v8_hvt ad=2.268n pd=0.138m as=3.276n ps=0.162m w=84 l=30
X35 SUB sky130_fd_sc_hd__dfrtp_1_0/a_761_289# sky130_fd_sc_hd__dfrtp_1_0/a_651_413# SUB sky130_fd_pr__pfet_01v8_hvt ad=2.814n pd=0.151m as=4.62n ps=0.194m w=84 l=30
X36 sky130_fd_sc_hd__buf_4_0/A sky130_fd_sc_hd__dfrtp_1_0/a_1283_21# SUB SUB sky130_fd_pr__nfet_01v8 ad=6.76n pd=0.364m as=8.348n ps=0.404m w=130 l=30
X37 sky130_fd_sc_hd__dfrtp_1_0/a_639_47# sky130_fd_sc_hd__dfrtp_1_0/a_193_47# sky130_fd_sc_hd__dfrtp_1_0/a_543_47# SUB sky130_fd_pr__nfet_01v8 ad=5.604n pd=0.22m as=2.376n ps=0.138m w=72 l=30
X38 SUB sky130_fd_sc_hd__dfrtp_1_0/a_1283_21# sky130_fd_sc_hd__dfrtp_1_0/a_1217_47# SUB sky130_fd_pr__nfet_01v8 ad=4.998n pd=0.203m as=2.676n ps=0.15m w=84 l=30
X39 sky130_fd_sc_hd__dfrtp_1_0/a_651_413# sky130_fd_sc_hd__inv_2_0/Y SUB SUB sky130_fd_pr__pfet_01v8_hvt ad=4.368n pd=0.272m as=2.814n ps=0.151m w=84 l=30
X40 SUB sky130_fd_sc_hd__clkbuf_2_1/X sky130_fd_sc_hd__dfrtp_1_0/a_27_47# SUB sky130_fd_pr__nfet_01v8 ad=2.268n pd=0.138m as=4.368n ps=0.272m w=84 l=30
X41 sky130_fd_sc_hd__dfrtp_1_0/a_761_289# sky130_fd_sc_hd__dfrtp_1_0/a_543_47# SUB SUB sky130_fd_pr__pfet_01v8_hvt ad=5.166n pd=0.237m as=8.736n ps=0.44m w=168 l=30
X42 sky130_fd_sc_hd__dfrtp_1_1/a_1217_47# sky130_fd_sc_hd__dfrtp_1_1/a_27_47# sky130_fd_sc_hd__dfrtp_1_1/a_1108_47# SUB sky130_fd_pr__nfet_01v8 ad=5.352n pd=0.3m as=5.688n ps=0.302m w=72 l=30
X43 sky130_fd_sc_hd__dfrtp_1_1/a_805_47# sky130_fd_sc_hd__dfrtp_1_1/a_761_289# sky130_fd_sc_hd__dfrtp_1_1/a_639_47# SUB sky130_fd_pr__nfet_01v8 ad=3.528n pd=0.252m as=11.208n ps=0.44m w=84 l=30
X44 sky130_fd_sc_hd__dfrtp_1_1/a_1108_47# sky130_fd_sc_hd__dfrtp_1_1/a_193_47# sky130_fd_sc_hd__dfrtp_1_1/a_761_289# SUB sky130_fd_pr__nfet_01v8 ad=0 pd=0 as=7.992n ps=0.394m w=72 l=30
X45 sky130_fd_sc_hd__dfrtp_1_1/a_1283_21# sky130_fd_sc_hd__dfrtp_1_1/a_1108_47# sky130_fd_sc_hd__dfrtp_1_1/a_1462_47# SUB sky130_fd_pr__nfet_01v8 ad=4.368n pd=0.272m as=5.124n ps=0.29m w=84 l=30
X46 sky130_fd_sc_hd__dfrtp_1_1/a_651_413# sky130_fd_sc_hd__dfrtp_1_1/a_27_47# sky130_fd_sc_hd__dfrtp_1_1/a_543_47# SUB sky130_fd_pr__pfet_01v8_hvt ad=13.608n pd=0.66m as=5.796n ps=0.306m w=84 l=30
X47 SUB sky130_fd_sc_hd__inv_2_0/Y sky130_fd_sc_hd__dfrtp_1_1/a_805_47# SUB sky130_fd_pr__nfet_01v8 ad=0.84005u pd=0.04351 as=0 ps=0 w=84 l=30
X48 sky130_fd_sc_hd__xnor2_1_2/A sky130_fd_sc_hd__dfrtp_1_1/a_1283_21# SUB SUB sky130_fd_pr__pfet_01v8_hvt ad=10.4n pd=0.504m as=1.2976u ps=0.06056 w=200 l=30
X49 SUB SUB sky130_fd_sc_hd__dfrtp_1_1/a_27_47# SUB sky130_fd_pr__pfet_01v8_hvt ad=0 pd=0 as=6.656n ps=0.36m w=128 l=30
X50 sky130_fd_sc_hd__dfrtp_1_1/a_448_47# sky130_fd_sc_hd__xnor2_1_2/Y SUB SUB sky130_fd_pr__pfet_01v8_hvt ad=5.208n pd=0.292m as=0 ps=0 w=84 l=30
X51 sky130_fd_sc_hd__dfrtp_1_1/a_761_289# sky130_fd_sc_hd__dfrtp_1_1/a_543_47# SUB SUB sky130_fd_pr__nfet_01v8 ad=0 pd=0 as=0 ps=0 w=128 l=30
X52 sky130_fd_sc_hd__dfrtp_1_1/a_193_47# sky130_fd_sc_hd__dfrtp_1_1/a_27_47# SUB SUB sky130_fd_pr__nfet_01v8 ad=4.368n pd=0.272m as=0 ps=0 w=84 l=30
X53 sky130_fd_sc_hd__dfrtp_1_1/a_1108_47# sky130_fd_sc_hd__dfrtp_1_1/a_27_47# sky130_fd_sc_hd__dfrtp_1_1/a_761_289# SUB sky130_fd_pr__pfet_01v8_hvt ad=4.704n pd=0.28m as=10.332n ps=0.474m w=84 l=30
X54 sky130_fd_sc_hd__dfrtp_1_1/a_543_47# sky130_fd_sc_hd__dfrtp_1_1/a_27_47# sky130_fd_sc_hd__dfrtp_1_1/a_448_47# SUB sky130_fd_pr__nfet_01v8 ad=4.752n pd=0.276m as=5.28n ps=0.298m w=72 l=30
X55 sky130_fd_sc_hd__dfrtp_1_1/a_1462_47# sky130_fd_sc_hd__inv_2_0/Y SUB SUB sky130_fd_pr__nfet_01v8 ad=0 pd=0 as=0 ps=0 w=84 l=30
X56 sky130_fd_sc_hd__dfrtp_1_1/a_543_47# sky130_fd_sc_hd__dfrtp_1_1/a_193_47# sky130_fd_sc_hd__dfrtp_1_1/a_448_47# SUB sky130_fd_pr__pfet_01v8_hvt ad=0 pd=0 as=0 ps=0 w=84 l=30
X57 sky130_fd_sc_hd__dfrtp_1_1/a_448_47# sky130_fd_sc_hd__xnor2_1_2/Y SUB SUB sky130_fd_pr__nfet_01v8 ad=0 pd=0 as=0 ps=0 w=84 l=30
X58 SUB sky130_fd_sc_hd__dfrtp_1_1/a_1283_21# sky130_fd_sc_hd__dfrtp_1_1/a_1270_413# SUB sky130_fd_pr__pfet_01v8_hvt ad=0 pd=0 as=4.536n ps=0.276m w=84 l=30
X59 SUB sky130_fd_sc_hd__dfrtp_1_1/a_1108_47# sky130_fd_sc_hd__dfrtp_1_1/a_1283_21# SUB sky130_fd_pr__pfet_01v8_hvt ad=0 pd=0 as=4.536n ps=0.276m w=84 l=30
X60 sky130_fd_sc_hd__dfrtp_1_1/a_1270_413# sky130_fd_sc_hd__dfrtp_1_1/a_193_47# sky130_fd_sc_hd__dfrtp_1_1/a_1108_47# SUB sky130_fd_pr__pfet_01v8_hvt ad=0 pd=0 as=0 ps=0 w=84 l=30
X61 sky130_fd_sc_hd__dfrtp_1_1/a_193_47# sky130_fd_sc_hd__dfrtp_1_1/a_27_47# SUB SUB sky130_fd_pr__pfet_01v8_hvt ad=6.656n pd=0.36m as=0 ps=0 w=128 l=30
X62 sky130_fd_sc_hd__dfrtp_1_1/a_1283_21# sky130_fd_sc_hd__inv_2_0/Y SUB SUB sky130_fd_pr__pfet_01v8_hvt ad=0 pd=0 as=0 ps=0 w=84 l=30
X63 SUB sky130_fd_sc_hd__dfrtp_1_1/a_761_289# sky130_fd_sc_hd__dfrtp_1_1/a_651_413# SUB sky130_fd_pr__pfet_01v8_hvt ad=0 pd=0 as=0 ps=0 w=84 l=30
X64 sky130_fd_sc_hd__xnor2_1_2/A sky130_fd_sc_hd__dfrtp_1_1/a_1283_21# SUB SUB sky130_fd_pr__nfet_01v8 ad=6.76n pd=0.364m as=0 ps=0 w=130 l=30
X65 sky130_fd_sc_hd__dfrtp_1_1/a_639_47# sky130_fd_sc_hd__dfrtp_1_1/a_193_47# sky130_fd_sc_hd__dfrtp_1_1/a_543_47# SUB sky130_fd_pr__nfet_01v8 ad=0 pd=0 as=0 ps=0 w=72 l=30
X66 SUB sky130_fd_sc_hd__dfrtp_1_1/a_1283_21# sky130_fd_sc_hd__dfrtp_1_1/a_1217_47# SUB sky130_fd_pr__nfet_01v8 ad=0 pd=0 as=0 ps=0 w=84 l=30
X67 sky130_fd_sc_hd__dfrtp_1_1/a_651_413# sky130_fd_sc_hd__inv_2_0/Y SUB SUB sky130_fd_pr__pfet_01v8_hvt ad=0 pd=0 as=0 ps=0 w=84 l=30
X68 SUB SUB sky130_fd_sc_hd__dfrtp_1_1/a_27_47# SUB sky130_fd_pr__nfet_01v8 ad=0 pd=0 as=4.368n ps=0.272m w=84 l=30
X69 sky130_fd_sc_hd__dfrtp_1_1/a_761_289# sky130_fd_sc_hd__dfrtp_1_1/a_543_47# SUB SUB sky130_fd_pr__pfet_01v8_hvt ad=0 pd=0 as=0 ps=0 w=168 l=30
X70 SUB sky130_fd_sc_hd__nor2_1_0/A sky130_fd_sc_hd__nor2_1_0/a_109_297# SUB sky130_fd_pr__pfet_01v8_hvt ad=10.4n pd=0.504m as=4.2n ps=0.242m w=200 l=30
X71 SUB sky130_fd_sc_hd__nor2_1_0/A sky130_fd_sc_hd__xor2_1_1/B SUB sky130_fd_pr__nfet_01v8 ad=6.76n pd=0.364m as=3.51n ps=0.184m w=130 l=30
X72 sky130_fd_sc_hd__nor2_1_0/a_109_297# sky130_fd_sc_hd__nor3_1_0/B sky130_fd_sc_hd__xor2_1_1/B SUB sky130_fd_pr__pfet_01v8_hvt ad=4.2n pd=0.242m as=10.4n ps=0.504m w=200 l=30
X73 sky130_fd_sc_hd__xor2_1_1/B sky130_fd_sc_hd__nor3_1_0/B SUB SUB sky130_fd_pr__nfet_01v8 ad=3.51n pd=0.184m as=6.76n ps=0.364m w=130 l=30
X74 sky130_fd_sc_hd__dfrtp_1_2/a_1217_47# sky130_fd_sc_hd__dfrtp_1_2/a_27_47# sky130_fd_sc_hd__dfrtp_1_2/a_1108_47# SUB sky130_fd_pr__nfet_01v8 ad=5.352n pd=0.3m as=5.688n ps=0.302m w=72 l=30
X75 sky130_fd_sc_hd__dfrtp_1_2/a_805_47# sky130_fd_sc_hd__dfrtp_1_2/a_761_289# sky130_fd_sc_hd__dfrtp_1_2/a_639_47# SUB sky130_fd_pr__nfet_01v8 ad=3.528n pd=0.252m as=11.208n ps=0.44m w=84 l=30
X76 sky130_fd_sc_hd__dfrtp_1_2/a_1108_47# sky130_fd_sc_hd__dfrtp_1_2/a_193_47# sky130_fd_sc_hd__dfrtp_1_2/a_761_289# SUB sky130_fd_pr__nfet_01v8 ad=0 pd=0 as=7.992n ps=0.394m w=72 l=30
X77 sky130_fd_sc_hd__dfrtp_1_2/a_1283_21# sky130_fd_sc_hd__dfrtp_1_2/a_1108_47# sky130_fd_sc_hd__dfrtp_1_2/a_1462_47# SUB sky130_fd_pr__nfet_01v8 ad=4.368n pd=0.272m as=5.124n ps=0.29m w=84 l=30
X78 sky130_fd_sc_hd__dfrtp_1_2/a_651_413# sky130_fd_sc_hd__dfrtp_1_2/a_27_47# sky130_fd_sc_hd__dfrtp_1_2/a_543_47# SUB sky130_fd_pr__pfet_01v8_hvt ad=13.608n pd=0.66m as=5.796n ps=0.306m w=84 l=30
X79 SUB sky130_fd_sc_hd__inv_2_0/Y sky130_fd_sc_hd__dfrtp_1_2/a_805_47# SUB sky130_fd_pr__nfet_01v8 ad=0 pd=0 as=0 ps=0 w=84 l=30
X80 sky130_fd_sc_hd__ha_1_0/A sky130_fd_sc_hd__dfrtp_1_2/a_1283_21# SUB SUB sky130_fd_pr__pfet_01v8_hvt ad=10.4n pd=0.504m as=0 ps=0 w=200 l=30
X81 SUB SUB sky130_fd_sc_hd__dfrtp_1_2/a_27_47# SUB sky130_fd_pr__pfet_01v8_hvt ad=0 pd=0 as=6.656n ps=0.36m w=128 l=30
X82 sky130_fd_sc_hd__dfrtp_1_2/a_448_47# sky130_fd_sc_hd__inv_1_0/Y SUB SUB sky130_fd_pr__pfet_01v8_hvt ad=5.208n pd=0.292m as=0 ps=0 w=84 l=30
X83 sky130_fd_sc_hd__dfrtp_1_2/a_761_289# sky130_fd_sc_hd__dfrtp_1_2/a_543_47# SUB SUB sky130_fd_pr__nfet_01v8 ad=0 pd=0 as=0 ps=0 w=128 l=30
X84 sky130_fd_sc_hd__dfrtp_1_2/a_193_47# sky130_fd_sc_hd__dfrtp_1_2/a_27_47# SUB SUB sky130_fd_pr__nfet_01v8 ad=4.368n pd=0.272m as=0 ps=0 w=84 l=30
X85 sky130_fd_sc_hd__dfrtp_1_2/a_1108_47# sky130_fd_sc_hd__dfrtp_1_2/a_27_47# sky130_fd_sc_hd__dfrtp_1_2/a_761_289# SUB sky130_fd_pr__pfet_01v8_hvt ad=4.704n pd=0.28m as=10.332n ps=0.474m w=84 l=30
X86 sky130_fd_sc_hd__dfrtp_1_2/a_543_47# sky130_fd_sc_hd__dfrtp_1_2/a_27_47# sky130_fd_sc_hd__dfrtp_1_2/a_448_47# SUB sky130_fd_pr__nfet_01v8 ad=4.752n pd=0.276m as=5.28n ps=0.298m w=72 l=30
X87 sky130_fd_sc_hd__dfrtp_1_2/a_1462_47# sky130_fd_sc_hd__inv_2_0/Y SUB SUB sky130_fd_pr__nfet_01v8 ad=0 pd=0 as=0 ps=0 w=84 l=30
X88 sky130_fd_sc_hd__dfrtp_1_2/a_543_47# sky130_fd_sc_hd__dfrtp_1_2/a_193_47# sky130_fd_sc_hd__dfrtp_1_2/a_448_47# SUB sky130_fd_pr__pfet_01v8_hvt ad=0 pd=0 as=0 ps=0 w=84 l=30
X89 sky130_fd_sc_hd__dfrtp_1_2/a_448_47# sky130_fd_sc_hd__inv_1_0/Y SUB SUB sky130_fd_pr__nfet_01v8 ad=0 pd=0 as=0 ps=0 w=84 l=30
X90 SUB sky130_fd_sc_hd__dfrtp_1_2/a_1283_21# sky130_fd_sc_hd__dfrtp_1_2/a_1270_413# SUB sky130_fd_pr__pfet_01v8_hvt ad=0 pd=0 as=4.536n ps=0.276m w=84 l=30
X91 SUB sky130_fd_sc_hd__dfrtp_1_2/a_1108_47# sky130_fd_sc_hd__dfrtp_1_2/a_1283_21# SUB sky130_fd_pr__pfet_01v8_hvt ad=0 pd=0 as=4.536n ps=0.276m w=84 l=30
X92 sky130_fd_sc_hd__dfrtp_1_2/a_1270_413# sky130_fd_sc_hd__dfrtp_1_2/a_193_47# sky130_fd_sc_hd__dfrtp_1_2/a_1108_47# SUB sky130_fd_pr__pfet_01v8_hvt ad=0 pd=0 as=0 ps=0 w=84 l=30
X93 sky130_fd_sc_hd__dfrtp_1_2/a_193_47# sky130_fd_sc_hd__dfrtp_1_2/a_27_47# SUB SUB sky130_fd_pr__pfet_01v8_hvt ad=6.656n pd=0.36m as=0 ps=0 w=128 l=30
X94 sky130_fd_sc_hd__dfrtp_1_2/a_1283_21# sky130_fd_sc_hd__inv_2_0/Y SUB SUB sky130_fd_pr__pfet_01v8_hvt ad=0 pd=0 as=0 ps=0 w=84 l=30
X95 SUB sky130_fd_sc_hd__dfrtp_1_2/a_761_289# sky130_fd_sc_hd__dfrtp_1_2/a_651_413# SUB sky130_fd_pr__pfet_01v8_hvt ad=0 pd=0 as=0 ps=0 w=84 l=30
X96 sky130_fd_sc_hd__ha_1_0/A sky130_fd_sc_hd__dfrtp_1_2/a_1283_21# SUB SUB sky130_fd_pr__nfet_01v8 ad=6.76n pd=0.364m as=0 ps=0 w=130 l=30
X97 sky130_fd_sc_hd__dfrtp_1_2/a_639_47# sky130_fd_sc_hd__dfrtp_1_2/a_193_47# sky130_fd_sc_hd__dfrtp_1_2/a_543_47# SUB sky130_fd_pr__nfet_01v8 ad=0 pd=0 as=0 ps=0 w=72 l=30
X98 SUB sky130_fd_sc_hd__dfrtp_1_2/a_1283_21# sky130_fd_sc_hd__dfrtp_1_2/a_1217_47# SUB sky130_fd_pr__nfet_01v8 ad=0 pd=0 as=0 ps=0 w=84 l=30
X99 sky130_fd_sc_hd__dfrtp_1_2/a_651_413# sky130_fd_sc_hd__inv_2_0/Y SUB SUB sky130_fd_pr__pfet_01v8_hvt ad=0 pd=0 as=0 ps=0 w=84 l=30
X100 SUB SUB sky130_fd_sc_hd__dfrtp_1_2/a_27_47# SUB sky130_fd_pr__nfet_01v8 ad=0 pd=0 as=4.368n ps=0.272m w=84 l=30
X101 sky130_fd_sc_hd__dfrtp_1_2/a_761_289# sky130_fd_sc_hd__dfrtp_1_2/a_543_47# SUB SUB sky130_fd_pr__pfet_01v8_hvt ad=0 pd=0 as=0 ps=0 w=168 l=30
X102 sky130_fd_sc_hd__xnor2_1_0/a_377_297# sky130_fd_sc_hd__buf_4_1/A SUB SUB sky130_fd_pr__pfet_01v8_hvt ad=4.2n pd=0.242m as=14.6n ps=0.346m w=200 l=30
X103 sky130_fd_sc_hd__xnor2_1_0/a_47_47# sky130_fd_sc_hd__nor2_1_0/A SUB SUB sky130_fd_pr__pfet_01v8_hvt ad=5.4n pd=0.254m as=12n ps=0.52m w=200 l=30
X104 sky130_fd_sc_hd__xnor2_1_0/a_129_47# sky130_fd_sc_hd__nor2_1_0/A sky130_fd_sc_hd__xnor2_1_0/a_47_47# SUB sky130_fd_pr__nfet_01v8 ad=2.73n pd=0.172m as=6.76n ps=0.364m w=130 l=30
X105 sky130_fd_sc_hd__xnor2_1_0/a_285_47# sky130_fd_sc_hd__nor2_1_0/A SUB SUB sky130_fd_pr__nfet_01v8 ad=3.51n pd=0.184m as=6.76n ps=0.364m w=130 l=30
X106 sky130_fd_sc_hd__xnor2_1_0/Y sky130_fd_sc_hd__xnor2_1_0/a_47_47# sky130_fd_sc_hd__xnor2_1_0/a_285_47# SUB sky130_fd_pr__nfet_01v8 ad=7.8n pd=0.38m as=3.51n ps=0.184m w=130 l=30
X107 SUB sky130_fd_sc_hd__buf_4_1/A sky130_fd_sc_hd__xnor2_1_0/a_129_47# SUB sky130_fd_pr__nfet_01v8 ad=3.51n pd=0.184m as=2.73n ps=0.172m w=130 l=30
X108 SUB sky130_fd_sc_hd__buf_4_1/A sky130_fd_sc_hd__xnor2_1_0/a_47_47# SUB sky130_fd_pr__pfet_01v8_hvt ad=14.6n pd=0.346m as=5.4n ps=0.254m w=200 l=30
X109 SUB sky130_fd_sc_hd__xnor2_1_0/a_47_47# sky130_fd_sc_hd__xnor2_1_0/Y SUB sky130_fd_pr__pfet_01v8_hvt ad=14.4n pd=0.544m as=6.6n ps=0.266m w=200 l=30
X110 sky130_fd_sc_hd__xnor2_1_0/Y sky130_fd_sc_hd__nor2_1_0/A sky130_fd_sc_hd__xnor2_1_0/a_377_297# SUB sky130_fd_pr__pfet_01v8_hvt ad=6.6n pd=0.266m as=4.2n ps=0.242m w=200 l=30
X111 sky130_fd_sc_hd__xnor2_1_0/a_285_47# sky130_fd_sc_hd__buf_4_1/A SUB SUB sky130_fd_pr__nfet_01v8 ad=6.76n pd=0.364m as=3.51n ps=0.184m w=130 l=30
X112 SUB sky130_fd_sc_hd__xnor2_1_2/A sky130_fd_sc_hd__clkbuf_4_0/a_27_47# SUB sky130_fd_pr__pfet_01v8_hvt ad=6.6n pd=0.266m as=10.6n ps=0.506m w=200 l=30
X113 SUB sky130_fd_sc_hd__clkbuf_4_0/a_27_47# count[3] SUB sky130_fd_pr__nfet_01v8 ad=4.872n pd=0.284m as=2.352n ps=0.14m w=84 l=30
X114 SUB sky130_fd_sc_hd__clkbuf_4_0/a_27_47# count[3] SUB sky130_fd_pr__nfet_01v8 ad=2.352n pd=0.14m as=2.352n ps=0.14m w=84 l=30
X115 count[3] sky130_fd_sc_hd__clkbuf_4_0/a_27_47# SUB SUB sky130_fd_pr__pfet_01v8_hvt ad=5.6n pd=0.256m as=5.6n ps=0.256m w=200 l=30
X116 count[3] sky130_fd_sc_hd__clkbuf_4_0/a_27_47# SUB SUB sky130_fd_pr__nfet_01v8 ad=2.352n pd=0.14m as=2.352n ps=0.14m w=84 l=30
X117 SUB sky130_fd_sc_hd__xnor2_1_2/A sky130_fd_sc_hd__clkbuf_4_0/a_27_47# SUB sky130_fd_pr__nfet_01v8 ad=2.814n pd=0.151m as=4.452n ps=0.274m w=84 l=30
X118 SUB sky130_fd_sc_hd__clkbuf_4_0/a_27_47# count[3] SUB sky130_fd_pr__pfet_01v8_hvt ad=12n pd=0.52m as=5.6n ps=0.256m w=200 l=30
X119 count[3] sky130_fd_sc_hd__clkbuf_4_0/a_27_47# SUB SUB sky130_fd_pr__nfet_01v8 ad=2.352n pd=0.14m as=2.814n ps=0.151m w=84 l=30
X120 count[3] sky130_fd_sc_hd__clkbuf_4_0/a_27_47# SUB SUB sky130_fd_pr__pfet_01v8_hvt ad=5.6n pd=0.256m as=6.6n ps=0.266m w=200 l=30
X121 SUB sky130_fd_sc_hd__clkbuf_4_0/a_27_47# count[3] SUB sky130_fd_pr__pfet_01v8_hvt ad=5.6n pd=0.256m as=5.6n ps=0.256m w=200 l=30
X122 sky130_fd_sc_hd__dfrtp_1_3/a_1217_47# sky130_fd_sc_hd__dfrtp_1_3/a_27_47# sky130_fd_sc_hd__dfrtp_1_3/a_1108_47# SUB sky130_fd_pr__nfet_01v8 ad=5.352n pd=0.3m as=5.688n ps=0.302m w=72 l=30
X123 sky130_fd_sc_hd__dfrtp_1_3/a_805_47# sky130_fd_sc_hd__dfrtp_1_3/a_761_289# sky130_fd_sc_hd__dfrtp_1_3/a_639_47# SUB sky130_fd_pr__nfet_01v8 ad=3.528n pd=0.252m as=11.208n ps=0.44m w=84 l=30
X124 sky130_fd_sc_hd__dfrtp_1_3/a_1108_47# sky130_fd_sc_hd__dfrtp_1_3/a_193_47# sky130_fd_sc_hd__dfrtp_1_3/a_761_289# SUB sky130_fd_pr__nfet_01v8 ad=0 pd=0 as=7.992n ps=0.394m w=72 l=30
X125 sky130_fd_sc_hd__dfrtp_1_3/a_1283_21# sky130_fd_sc_hd__dfrtp_1_3/a_1108_47# sky130_fd_sc_hd__dfrtp_1_3/a_1462_47# SUB sky130_fd_pr__nfet_01v8 ad=4.368n pd=0.272m as=5.124n ps=0.29m w=84 l=30
X126 sky130_fd_sc_hd__dfrtp_1_3/a_651_413# sky130_fd_sc_hd__dfrtp_1_3/a_27_47# sky130_fd_sc_hd__dfrtp_1_3/a_543_47# SUB sky130_fd_pr__pfet_01v8_hvt ad=13.608n pd=0.66m as=5.796n ps=0.306m w=84 l=30
X127 SUB sky130_fd_sc_hd__inv_2_0/Y sky130_fd_sc_hd__dfrtp_1_3/a_805_47# SUB sky130_fd_pr__nfet_01v8 ad=0 pd=0 as=0 ps=0 w=84 l=30
X128 sky130_fd_sc_hd__ha_1_0/B sky130_fd_sc_hd__dfrtp_1_3/a_1283_21# SUB SUB sky130_fd_pr__pfet_01v8_hvt ad=10.4n pd=0.504m as=0 ps=0 w=200 l=30
X129 SUB SUB sky130_fd_sc_hd__dfrtp_1_3/a_27_47# SUB sky130_fd_pr__pfet_01v8_hvt ad=0 pd=0 as=6.656n ps=0.36m w=128 l=30
X130 sky130_fd_sc_hd__dfrtp_1_3/a_448_47# sky130_fd_sc_hd__ha_1_0/SUM SUB SUB sky130_fd_pr__pfet_01v8_hvt ad=5.208n pd=0.292m as=0 ps=0 w=84 l=30
X131 sky130_fd_sc_hd__dfrtp_1_3/a_761_289# sky130_fd_sc_hd__dfrtp_1_3/a_543_47# SUB SUB sky130_fd_pr__nfet_01v8 ad=0 pd=0 as=0 ps=0 w=128 l=30
X132 sky130_fd_sc_hd__dfrtp_1_3/a_193_47# sky130_fd_sc_hd__dfrtp_1_3/a_27_47# SUB SUB sky130_fd_pr__nfet_01v8 ad=4.368n pd=0.272m as=0 ps=0 w=84 l=30
X133 sky130_fd_sc_hd__dfrtp_1_3/a_1108_47# sky130_fd_sc_hd__dfrtp_1_3/a_27_47# sky130_fd_sc_hd__dfrtp_1_3/a_761_289# SUB sky130_fd_pr__pfet_01v8_hvt ad=4.704n pd=0.28m as=10.332n ps=0.474m w=84 l=30
X134 sky130_fd_sc_hd__dfrtp_1_3/a_543_47# sky130_fd_sc_hd__dfrtp_1_3/a_27_47# sky130_fd_sc_hd__dfrtp_1_3/a_448_47# SUB sky130_fd_pr__nfet_01v8 ad=4.752n pd=0.276m as=5.28n ps=0.298m w=72 l=30
X135 sky130_fd_sc_hd__dfrtp_1_3/a_1462_47# sky130_fd_sc_hd__inv_2_0/Y SUB SUB sky130_fd_pr__nfet_01v8 ad=0 pd=0 as=0 ps=0 w=84 l=30
X136 sky130_fd_sc_hd__dfrtp_1_3/a_543_47# sky130_fd_sc_hd__dfrtp_1_3/a_193_47# sky130_fd_sc_hd__dfrtp_1_3/a_448_47# SUB sky130_fd_pr__pfet_01v8_hvt ad=0 pd=0 as=0 ps=0 w=84 l=30
X137 sky130_fd_sc_hd__dfrtp_1_3/a_448_47# sky130_fd_sc_hd__ha_1_0/SUM SUB SUB sky130_fd_pr__nfet_01v8 ad=0 pd=0 as=0 ps=0 w=84 l=30
X138 SUB sky130_fd_sc_hd__dfrtp_1_3/a_1283_21# sky130_fd_sc_hd__dfrtp_1_3/a_1270_413# SUB sky130_fd_pr__pfet_01v8_hvt ad=0 pd=0 as=4.536n ps=0.276m w=84 l=30
X139 SUB sky130_fd_sc_hd__dfrtp_1_3/a_1108_47# sky130_fd_sc_hd__dfrtp_1_3/a_1283_21# SUB sky130_fd_pr__pfet_01v8_hvt ad=0 pd=0 as=4.536n ps=0.276m w=84 l=30
X140 sky130_fd_sc_hd__dfrtp_1_3/a_1270_413# sky130_fd_sc_hd__dfrtp_1_3/a_193_47# sky130_fd_sc_hd__dfrtp_1_3/a_1108_47# SUB sky130_fd_pr__pfet_01v8_hvt ad=0 pd=0 as=0 ps=0 w=84 l=30
X141 sky130_fd_sc_hd__dfrtp_1_3/a_193_47# sky130_fd_sc_hd__dfrtp_1_3/a_27_47# SUB SUB sky130_fd_pr__pfet_01v8_hvt ad=6.656n pd=0.36m as=0 ps=0 w=128 l=30
X142 sky130_fd_sc_hd__dfrtp_1_3/a_1283_21# sky130_fd_sc_hd__inv_2_0/Y SUB SUB sky130_fd_pr__pfet_01v8_hvt ad=0 pd=0 as=0 ps=0 w=84 l=30
X143 SUB sky130_fd_sc_hd__dfrtp_1_3/a_761_289# sky130_fd_sc_hd__dfrtp_1_3/a_651_413# SUB sky130_fd_pr__pfet_01v8_hvt ad=0 pd=0 as=0 ps=0 w=84 l=30
X144 sky130_fd_sc_hd__ha_1_0/B sky130_fd_sc_hd__dfrtp_1_3/a_1283_21# SUB SUB sky130_fd_pr__nfet_01v8 ad=6.76n pd=0.364m as=0 ps=0 w=130 l=30
X145 sky130_fd_sc_hd__dfrtp_1_3/a_639_47# sky130_fd_sc_hd__dfrtp_1_3/a_193_47# sky130_fd_sc_hd__dfrtp_1_3/a_543_47# SUB sky130_fd_pr__nfet_01v8 ad=0 pd=0 as=0 ps=0 w=72 l=30
X146 SUB sky130_fd_sc_hd__dfrtp_1_3/a_1283_21# sky130_fd_sc_hd__dfrtp_1_3/a_1217_47# SUB sky130_fd_pr__nfet_01v8 ad=0 pd=0 as=0 ps=0 w=84 l=30
X147 sky130_fd_sc_hd__dfrtp_1_3/a_651_413# sky130_fd_sc_hd__inv_2_0/Y SUB SUB sky130_fd_pr__pfet_01v8_hvt ad=0 pd=0 as=0 ps=0 w=84 l=30
X148 SUB SUB sky130_fd_sc_hd__dfrtp_1_3/a_27_47# SUB sky130_fd_pr__nfet_01v8 ad=0 pd=0 as=4.368n ps=0.272m w=84 l=30
X149 sky130_fd_sc_hd__dfrtp_1_3/a_761_289# sky130_fd_sc_hd__dfrtp_1_3/a_543_47# SUB SUB sky130_fd_pr__pfet_01v8_hvt ad=0 pd=0 as=0 ps=0 w=168 l=30
X150 sky130_fd_sc_hd__xnor2_1_1/a_377_297# sky130_fd_sc_hd__buf_4_2/A SUB SUB sky130_fd_pr__pfet_01v8_hvt ad=8.4n pd=0.484m as=0 ps=0 w=200 l=30
X151 sky130_fd_sc_hd__xnor2_1_1/a_47_47# sky130_fd_sc_hd__xnor2_1_1/B SUB SUB sky130_fd_pr__pfet_01v8_hvt ad=10.8n pd=0.508m as=0 ps=0 w=200 l=30
X152 sky130_fd_sc_hd__xnor2_1_1/a_129_47# sky130_fd_sc_hd__xnor2_1_1/B sky130_fd_sc_hd__xnor2_1_1/a_47_47# SUB sky130_fd_pr__nfet_01v8 ad=5.46n pd=0.344m as=6.76n ps=0.364m w=130 l=30
X153 sky130_fd_sc_hd__xnor2_1_1/a_285_47# sky130_fd_sc_hd__xnor2_1_1/B SUB SUB sky130_fd_pr__nfet_01v8 ad=13.78n pd=0.732m as=0 ps=0 w=130 l=30
X154 sky130_fd_sc_hd__xnor2_1_1/Y sky130_fd_sc_hd__xnor2_1_1/a_47_47# sky130_fd_sc_hd__xnor2_1_1/a_285_47# SUB sky130_fd_pr__nfet_01v8 ad=7.8n pd=0.38m as=0 ps=0 w=130 l=30
X155 SUB sky130_fd_sc_hd__buf_4_2/A sky130_fd_sc_hd__xnor2_1_1/a_129_47# SUB sky130_fd_pr__nfet_01v8 ad=0 pd=0 as=0 ps=0 w=130 l=30
X156 SUB sky130_fd_sc_hd__buf_4_2/A sky130_fd_sc_hd__xnor2_1_1/a_47_47# SUB sky130_fd_pr__pfet_01v8_hvt ad=0 pd=0 as=0 ps=0 w=200 l=30
X157 SUB sky130_fd_sc_hd__xnor2_1_1/a_47_47# sky130_fd_sc_hd__xnor2_1_1/Y SUB sky130_fd_pr__pfet_01v8_hvt ad=0 pd=0 as=13.2n ps=0.532m w=200 l=30
X158 sky130_fd_sc_hd__xnor2_1_1/Y sky130_fd_sc_hd__xnor2_1_1/B sky130_fd_sc_hd__xnor2_1_1/a_377_297# SUB sky130_fd_pr__pfet_01v8_hvt ad=0 pd=0 as=0 ps=0 w=200 l=30
X159 sky130_fd_sc_hd__xnor2_1_1/a_285_47# sky130_fd_sc_hd__buf_4_2/A SUB SUB sky130_fd_pr__nfet_01v8 ad=0 pd=0 as=0 ps=0 w=130 l=30
X160 SUB sky130_fd_sc_hd__ha_1_0/A sky130_fd_sc_hd__clkbuf_4_1/a_27_47# SUB sky130_fd_pr__pfet_01v8_hvt ad=0 pd=0 as=10.6n ps=0.506m w=200 l=30
X161 SUB sky130_fd_sc_hd__clkbuf_4_1/a_27_47# count[0] SUB sky130_fd_pr__nfet_01v8 ad=0 pd=0 as=9.408n ps=0.56m w=84 l=30
X162 SUB sky130_fd_sc_hd__clkbuf_4_1/a_27_47# count[0] SUB sky130_fd_pr__nfet_01v8 ad=0 pd=0 as=0 ps=0 w=84 l=30
X163 count[0] sky130_fd_sc_hd__clkbuf_4_1/a_27_47# SUB SUB sky130_fd_pr__pfet_01v8_hvt ad=22.4n pd=1.024m as=0 ps=0 w=200 l=30
X164 count[0] sky130_fd_sc_hd__clkbuf_4_1/a_27_47# SUB SUB sky130_fd_pr__nfet_01v8 ad=0 pd=0 as=0 ps=0 w=84 l=30
X165 SUB sky130_fd_sc_hd__ha_1_0/A sky130_fd_sc_hd__clkbuf_4_1/a_27_47# SUB sky130_fd_pr__nfet_01v8 ad=0 pd=0 as=4.452n ps=0.274m w=84 l=30
X166 SUB sky130_fd_sc_hd__clkbuf_4_1/a_27_47# count[0] SUB sky130_fd_pr__pfet_01v8_hvt ad=0 pd=0 as=0 ps=0 w=200 l=30
X167 count[0] sky130_fd_sc_hd__clkbuf_4_1/a_27_47# SUB SUB sky130_fd_pr__nfet_01v8 ad=0 pd=0 as=0 ps=0 w=84 l=30
X168 count[0] sky130_fd_sc_hd__clkbuf_4_1/a_27_47# SUB SUB sky130_fd_pr__pfet_01v8_hvt ad=0 pd=0 as=0 ps=0 w=200 l=30
X169 SUB sky130_fd_sc_hd__clkbuf_4_1/a_27_47# count[0] SUB sky130_fd_pr__pfet_01v8_hvt ad=0 pd=0 as=0 ps=0 w=200 l=30
X170 sky130_fd_sc_hd__dfrtp_1_4/a_1217_47# sky130_fd_sc_hd__dfrtp_1_4/a_27_47# sky130_fd_sc_hd__dfrtp_1_4/a_1108_47# SUB sky130_fd_pr__nfet_01v8 ad=5.352n pd=0.3m as=5.688n ps=0.302m w=72 l=30
X171 sky130_fd_sc_hd__dfrtp_1_4/a_805_47# sky130_fd_sc_hd__dfrtp_1_4/a_761_289# sky130_fd_sc_hd__dfrtp_1_4/a_639_47# SUB sky130_fd_pr__nfet_01v8 ad=3.528n pd=0.252m as=11.208n ps=0.44m w=84 l=30
X172 sky130_fd_sc_hd__dfrtp_1_4/a_1108_47# sky130_fd_sc_hd__dfrtp_1_4/a_193_47# sky130_fd_sc_hd__dfrtp_1_4/a_761_289# SUB sky130_fd_pr__nfet_01v8 ad=0 pd=0 as=7.992n ps=0.394m w=72 l=30
X173 sky130_fd_sc_hd__dfrtp_1_4/a_1283_21# sky130_fd_sc_hd__dfrtp_1_4/a_1108_47# sky130_fd_sc_hd__dfrtp_1_4/a_1462_47# SUB sky130_fd_pr__nfet_01v8 ad=4.368n pd=0.272m as=5.124n ps=0.29m w=84 l=30
X174 sky130_fd_sc_hd__dfrtp_1_4/a_651_413# sky130_fd_sc_hd__dfrtp_1_4/a_27_47# sky130_fd_sc_hd__dfrtp_1_4/a_543_47# SUB sky130_fd_pr__pfet_01v8_hvt ad=13.608n pd=0.66m as=5.796n ps=0.306m w=84 l=30
X175 SUB sky130_fd_sc_hd__inv_2_0/Y sky130_fd_sc_hd__dfrtp_1_4/a_805_47# SUB sky130_fd_pr__nfet_01v8 ad=0 pd=0 as=0 ps=0 w=84 l=30
X176 sky130_fd_sc_hd__buf_4_1/A sky130_fd_sc_hd__dfrtp_1_4/a_1283_21# SUB SUB sky130_fd_pr__pfet_01v8_hvt ad=10.4n pd=0.504m as=0 ps=0 w=200 l=30
X177 SUB sky130_fd_sc_hd__clkbuf_2_1/X sky130_fd_sc_hd__dfrtp_1_4/a_27_47# SUB sky130_fd_pr__pfet_01v8_hvt ad=0 pd=0 as=6.656n ps=0.36m w=128 l=30
X178 sky130_fd_sc_hd__dfrtp_1_4/a_448_47# sky130_fd_sc_hd__xnor2_1_0/Y SUB SUB sky130_fd_pr__pfet_01v8_hvt ad=5.208n pd=0.292m as=0 ps=0 w=84 l=30
X179 sky130_fd_sc_hd__dfrtp_1_4/a_761_289# sky130_fd_sc_hd__dfrtp_1_4/a_543_47# SUB SUB sky130_fd_pr__nfet_01v8 ad=0 pd=0 as=0 ps=0 w=128 l=30
X180 sky130_fd_sc_hd__dfrtp_1_4/a_193_47# sky130_fd_sc_hd__dfrtp_1_4/a_27_47# SUB SUB sky130_fd_pr__nfet_01v8 ad=4.368n pd=0.272m as=0 ps=0 w=84 l=30
X181 sky130_fd_sc_hd__dfrtp_1_4/a_1108_47# sky130_fd_sc_hd__dfrtp_1_4/a_27_47# sky130_fd_sc_hd__dfrtp_1_4/a_761_289# SUB sky130_fd_pr__pfet_01v8_hvt ad=4.704n pd=0.28m as=10.332n ps=0.474m w=84 l=30
X182 sky130_fd_sc_hd__dfrtp_1_4/a_543_47# sky130_fd_sc_hd__dfrtp_1_4/a_27_47# sky130_fd_sc_hd__dfrtp_1_4/a_448_47# SUB sky130_fd_pr__nfet_01v8 ad=4.752n pd=0.276m as=5.28n ps=0.298m w=72 l=30
X183 sky130_fd_sc_hd__dfrtp_1_4/a_1462_47# sky130_fd_sc_hd__inv_2_0/Y SUB SUB sky130_fd_pr__nfet_01v8 ad=0 pd=0 as=0 ps=0 w=84 l=30
X184 sky130_fd_sc_hd__dfrtp_1_4/a_543_47# sky130_fd_sc_hd__dfrtp_1_4/a_193_47# sky130_fd_sc_hd__dfrtp_1_4/a_448_47# SUB sky130_fd_pr__pfet_01v8_hvt ad=0 pd=0 as=0 ps=0 w=84 l=30
X185 sky130_fd_sc_hd__dfrtp_1_4/a_448_47# sky130_fd_sc_hd__xnor2_1_0/Y SUB SUB sky130_fd_pr__nfet_01v8 ad=0 pd=0 as=0 ps=0 w=84 l=30
X186 SUB sky130_fd_sc_hd__dfrtp_1_4/a_1283_21# sky130_fd_sc_hd__dfrtp_1_4/a_1270_413# SUB sky130_fd_pr__pfet_01v8_hvt ad=0 pd=0 as=4.536n ps=0.276m w=84 l=30
X187 SUB sky130_fd_sc_hd__dfrtp_1_4/a_1108_47# sky130_fd_sc_hd__dfrtp_1_4/a_1283_21# SUB sky130_fd_pr__pfet_01v8_hvt ad=0 pd=0 as=4.536n ps=0.276m w=84 l=30
X188 sky130_fd_sc_hd__dfrtp_1_4/a_1270_413# sky130_fd_sc_hd__dfrtp_1_4/a_193_47# sky130_fd_sc_hd__dfrtp_1_4/a_1108_47# SUB sky130_fd_pr__pfet_01v8_hvt ad=0 pd=0 as=0 ps=0 w=84 l=30
X189 sky130_fd_sc_hd__dfrtp_1_4/a_193_47# sky130_fd_sc_hd__dfrtp_1_4/a_27_47# SUB SUB sky130_fd_pr__pfet_01v8_hvt ad=6.656n pd=0.36m as=0 ps=0 w=128 l=30
X190 sky130_fd_sc_hd__dfrtp_1_4/a_1283_21# sky130_fd_sc_hd__inv_2_0/Y SUB SUB sky130_fd_pr__pfet_01v8_hvt ad=0 pd=0 as=0 ps=0 w=84 l=30
X191 SUB sky130_fd_sc_hd__dfrtp_1_4/a_761_289# sky130_fd_sc_hd__dfrtp_1_4/a_651_413# SUB sky130_fd_pr__pfet_01v8_hvt ad=0 pd=0 as=0 ps=0 w=84 l=30
X192 sky130_fd_sc_hd__buf_4_1/A sky130_fd_sc_hd__dfrtp_1_4/a_1283_21# SUB SUB sky130_fd_pr__nfet_01v8 ad=6.76n pd=0.364m as=0 ps=0 w=130 l=30
X193 sky130_fd_sc_hd__dfrtp_1_4/a_639_47# sky130_fd_sc_hd__dfrtp_1_4/a_193_47# sky130_fd_sc_hd__dfrtp_1_4/a_543_47# SUB sky130_fd_pr__nfet_01v8 ad=0 pd=0 as=0 ps=0 w=72 l=30
X194 SUB sky130_fd_sc_hd__dfrtp_1_4/a_1283_21# sky130_fd_sc_hd__dfrtp_1_4/a_1217_47# SUB sky130_fd_pr__nfet_01v8 ad=0 pd=0 as=0 ps=0 w=84 l=30
X195 sky130_fd_sc_hd__dfrtp_1_4/a_651_413# sky130_fd_sc_hd__inv_2_0/Y SUB SUB sky130_fd_pr__pfet_01v8_hvt ad=0 pd=0 as=0 ps=0 w=84 l=30
X196 SUB sky130_fd_sc_hd__clkbuf_2_1/X sky130_fd_sc_hd__dfrtp_1_4/a_27_47# SUB sky130_fd_pr__nfet_01v8 ad=0 pd=0 as=4.368n ps=0.272m w=84 l=30
X197 sky130_fd_sc_hd__dfrtp_1_4/a_761_289# sky130_fd_sc_hd__dfrtp_1_4/a_543_47# SUB SUB sky130_fd_pr__pfet_01v8_hvt ad=0 pd=0 as=0 ps=0 w=168 l=30
X198 sky130_fd_sc_hd__xnor2_1_2/a_377_297# sky130_fd_sc_hd__xnor2_1_2/A SUB SUB sky130_fd_pr__pfet_01v8_hvt ad=8.4n pd=0.484m as=0 ps=0 w=200 l=30
X199 sky130_fd_sc_hd__xnor2_1_2/a_47_47# sky130_fd_sc_hd__xnor2_1_2/B SUB SUB sky130_fd_pr__pfet_01v8_hvt ad=10.8n pd=0.508m as=0 ps=0 w=200 l=30
X200 sky130_fd_sc_hd__xnor2_1_2/a_129_47# sky130_fd_sc_hd__xnor2_1_2/B sky130_fd_sc_hd__xnor2_1_2/a_47_47# SUB sky130_fd_pr__nfet_01v8 ad=5.46n pd=0.344m as=6.76n ps=0.364m w=130 l=30
X201 sky130_fd_sc_hd__xnor2_1_2/a_285_47# sky130_fd_sc_hd__xnor2_1_2/B SUB SUB sky130_fd_pr__nfet_01v8 ad=13.78n pd=0.732m as=0 ps=0 w=130 l=30
X202 sky130_fd_sc_hd__xnor2_1_2/Y sky130_fd_sc_hd__xnor2_1_2/a_47_47# sky130_fd_sc_hd__xnor2_1_2/a_285_47# SUB sky130_fd_pr__nfet_01v8 ad=7.8n pd=0.38m as=0 ps=0 w=130 l=30
X203 SUB sky130_fd_sc_hd__xnor2_1_2/A sky130_fd_sc_hd__xnor2_1_2/a_129_47# SUB sky130_fd_pr__nfet_01v8 ad=0 pd=0 as=0 ps=0 w=130 l=30
X204 SUB sky130_fd_sc_hd__xnor2_1_2/A sky130_fd_sc_hd__xnor2_1_2/a_47_47# SUB sky130_fd_pr__pfet_01v8_hvt ad=0 pd=0 as=0 ps=0 w=200 l=30
X205 SUB sky130_fd_sc_hd__xnor2_1_2/a_47_47# sky130_fd_sc_hd__xnor2_1_2/Y SUB sky130_fd_pr__pfet_01v8_hvt ad=0 pd=0 as=13.2n ps=0.532m w=200 l=30
X206 sky130_fd_sc_hd__xnor2_1_2/Y sky130_fd_sc_hd__xnor2_1_2/B sky130_fd_sc_hd__xnor2_1_2/a_377_297# SUB sky130_fd_pr__pfet_01v8_hvt ad=0 pd=0 as=0 ps=0 w=200 l=30
X207 sky130_fd_sc_hd__xnor2_1_2/a_285_47# sky130_fd_sc_hd__xnor2_1_2/A SUB SUB sky130_fd_pr__nfet_01v8 ad=0 pd=0 as=0 ps=0 w=130 l=30
X208 SUB sky130_fd_sc_hd__ha_1_0/B sky130_fd_sc_hd__clkbuf_4_2/a_27_47# SUB sky130_fd_pr__pfet_01v8_hvt ad=0 pd=0 as=10.6n ps=0.506m w=200 l=30
X209 SUB sky130_fd_sc_hd__clkbuf_4_2/a_27_47# count[1] SUB sky130_fd_pr__nfet_01v8 ad=0 pd=0 as=9.408n ps=0.56m w=84 l=30
X210 SUB sky130_fd_sc_hd__clkbuf_4_2/a_27_47# count[1] SUB sky130_fd_pr__nfet_01v8 ad=0 pd=0 as=0 ps=0 w=84 l=30
X211 count[1] sky130_fd_sc_hd__clkbuf_4_2/a_27_47# SUB SUB sky130_fd_pr__pfet_01v8_hvt ad=22.4n pd=1.024m as=0 ps=0 w=200 l=30
X212 count[1] sky130_fd_sc_hd__clkbuf_4_2/a_27_47# SUB SUB sky130_fd_pr__nfet_01v8 ad=0 pd=0 as=0 ps=0 w=84 l=30
X213 SUB sky130_fd_sc_hd__ha_1_0/B sky130_fd_sc_hd__clkbuf_4_2/a_27_47# SUB sky130_fd_pr__nfet_01v8 ad=0 pd=0 as=4.452n ps=0.274m w=84 l=30
X214 SUB sky130_fd_sc_hd__clkbuf_4_2/a_27_47# count[1] SUB sky130_fd_pr__pfet_01v8_hvt ad=0 pd=0 as=0 ps=0 w=200 l=30
X215 count[1] sky130_fd_sc_hd__clkbuf_4_2/a_27_47# SUB SUB sky130_fd_pr__nfet_01v8 ad=0 pd=0 as=0 ps=0 w=84 l=30
X216 count[1] sky130_fd_sc_hd__clkbuf_4_2/a_27_47# SUB SUB sky130_fd_pr__pfet_01v8_hvt ad=0 pd=0 as=0 ps=0 w=200 l=30
X217 SUB sky130_fd_sc_hd__clkbuf_4_2/a_27_47# count[1] SUB sky130_fd_pr__pfet_01v8_hvt ad=0 pd=0 as=0 ps=0 w=200 l=30
X218 sky130_fd_sc_hd__dfrtp_1_5/a_1217_47# sky130_fd_sc_hd__dfrtp_1_5/a_27_47# sky130_fd_sc_hd__dfrtp_1_5/a_1108_47# SUB sky130_fd_pr__nfet_01v8 ad=5.352n pd=0.3m as=5.688n ps=0.302m w=72 l=30
X219 sky130_fd_sc_hd__dfrtp_1_5/a_805_47# sky130_fd_sc_hd__dfrtp_1_5/a_761_289# sky130_fd_sc_hd__dfrtp_1_5/a_639_47# SUB sky130_fd_pr__nfet_01v8 ad=3.528n pd=0.252m as=11.208n ps=0.44m w=84 l=30
X220 sky130_fd_sc_hd__dfrtp_1_5/a_1108_47# sky130_fd_sc_hd__dfrtp_1_5/a_193_47# sky130_fd_sc_hd__dfrtp_1_5/a_761_289# SUB sky130_fd_pr__nfet_01v8 ad=0 pd=0 as=7.992n ps=0.394m w=72 l=30
X221 sky130_fd_sc_hd__dfrtp_1_5/a_1283_21# sky130_fd_sc_hd__dfrtp_1_5/a_1108_47# sky130_fd_sc_hd__dfrtp_1_5/a_1462_47# SUB sky130_fd_pr__nfet_01v8 ad=4.368n pd=0.272m as=5.124n ps=0.29m w=84 l=30
X222 sky130_fd_sc_hd__dfrtp_1_5/a_651_413# sky130_fd_sc_hd__dfrtp_1_5/a_27_47# sky130_fd_sc_hd__dfrtp_1_5/a_543_47# SUB sky130_fd_pr__pfet_01v8_hvt ad=13.608n pd=0.66m as=5.796n ps=0.306m w=84 l=30
X223 SUB sky130_fd_sc_hd__inv_2_0/Y sky130_fd_sc_hd__dfrtp_1_5/a_805_47# SUB sky130_fd_pr__nfet_01v8 ad=0 pd=0 as=0 ps=0 w=84 l=30
X224 SUB sky130_fd_sc_hd__dfrtp_1_5/a_1283_21# SUB SUB sky130_fd_pr__pfet_01v8_hvt ad=0 pd=0 as=0 ps=0 w=200 l=30
X225 SUB sky130_fd_sc_hd__clkbuf_2_1/X sky130_fd_sc_hd__dfrtp_1_5/a_27_47# SUB sky130_fd_pr__pfet_01v8_hvt ad=0 pd=0 as=6.656n ps=0.36m w=128 l=30
X226 sky130_fd_sc_hd__dfrtp_1_5/a_448_47# sky130_fd_sc_hd__xor2_1_1/X SUB SUB sky130_fd_pr__pfet_01v8_hvt ad=5.208n pd=0.292m as=0 ps=0 w=84 l=30
X227 sky130_fd_sc_hd__dfrtp_1_5/a_761_289# sky130_fd_sc_hd__dfrtp_1_5/a_543_47# SUB SUB sky130_fd_pr__nfet_01v8 ad=0 pd=0 as=0 ps=0 w=128 l=30
X228 sky130_fd_sc_hd__dfrtp_1_5/a_193_47# sky130_fd_sc_hd__dfrtp_1_5/a_27_47# SUB SUB sky130_fd_pr__nfet_01v8 ad=4.368n pd=0.272m as=0 ps=0 w=84 l=30
X229 sky130_fd_sc_hd__dfrtp_1_5/a_1108_47# sky130_fd_sc_hd__dfrtp_1_5/a_27_47# sky130_fd_sc_hd__dfrtp_1_5/a_761_289# SUB sky130_fd_pr__pfet_01v8_hvt ad=4.704n pd=0.28m as=10.332n ps=0.474m w=84 l=30
X230 sky130_fd_sc_hd__dfrtp_1_5/a_543_47# sky130_fd_sc_hd__dfrtp_1_5/a_27_47# sky130_fd_sc_hd__dfrtp_1_5/a_448_47# SUB sky130_fd_pr__nfet_01v8 ad=4.752n pd=0.276m as=5.28n ps=0.298m w=72 l=30
X231 sky130_fd_sc_hd__dfrtp_1_5/a_1462_47# sky130_fd_sc_hd__inv_2_0/Y SUB SUB sky130_fd_pr__nfet_01v8 ad=0 pd=0 as=0 ps=0 w=84 l=30
X232 sky130_fd_sc_hd__dfrtp_1_5/a_543_47# sky130_fd_sc_hd__dfrtp_1_5/a_193_47# sky130_fd_sc_hd__dfrtp_1_5/a_448_47# SUB sky130_fd_pr__pfet_01v8_hvt ad=0 pd=0 as=0 ps=0 w=84 l=30
X233 sky130_fd_sc_hd__dfrtp_1_5/a_448_47# sky130_fd_sc_hd__xor2_1_1/X SUB SUB sky130_fd_pr__nfet_01v8 ad=0 pd=0 as=0 ps=0 w=84 l=30
X234 SUB sky130_fd_sc_hd__dfrtp_1_5/a_1283_21# sky130_fd_sc_hd__dfrtp_1_5/a_1270_413# SUB sky130_fd_pr__pfet_01v8_hvt ad=0 pd=0 as=4.536n ps=0.276m w=84 l=30
X235 SUB sky130_fd_sc_hd__dfrtp_1_5/a_1108_47# sky130_fd_sc_hd__dfrtp_1_5/a_1283_21# SUB sky130_fd_pr__pfet_01v8_hvt ad=0 pd=0 as=4.536n ps=0.276m w=84 l=30
X236 sky130_fd_sc_hd__dfrtp_1_5/a_1270_413# sky130_fd_sc_hd__dfrtp_1_5/a_193_47# sky130_fd_sc_hd__dfrtp_1_5/a_1108_47# SUB sky130_fd_pr__pfet_01v8_hvt ad=0 pd=0 as=0 ps=0 w=84 l=30
X237 sky130_fd_sc_hd__dfrtp_1_5/a_193_47# sky130_fd_sc_hd__dfrtp_1_5/a_27_47# SUB SUB sky130_fd_pr__pfet_01v8_hvt ad=6.656n pd=0.36m as=0 ps=0 w=128 l=30
X238 sky130_fd_sc_hd__dfrtp_1_5/a_1283_21# sky130_fd_sc_hd__inv_2_0/Y SUB SUB sky130_fd_pr__pfet_01v8_hvt ad=0 pd=0 as=0 ps=0 w=84 l=30
X239 SUB sky130_fd_sc_hd__dfrtp_1_5/a_761_289# sky130_fd_sc_hd__dfrtp_1_5/a_651_413# SUB sky130_fd_pr__pfet_01v8_hvt ad=0 pd=0 as=0 ps=0 w=84 l=30
X240 SUB sky130_fd_sc_hd__dfrtp_1_5/a_1283_21# SUB SUB sky130_fd_pr__nfet_01v8 ad=0 pd=0 as=0 ps=0 w=130 l=30
X241 sky130_fd_sc_hd__dfrtp_1_5/a_639_47# sky130_fd_sc_hd__dfrtp_1_5/a_193_47# sky130_fd_sc_hd__dfrtp_1_5/a_543_47# SUB sky130_fd_pr__nfet_01v8 ad=0 pd=0 as=0 ps=0 w=72 l=30
X242 SUB sky130_fd_sc_hd__dfrtp_1_5/a_1283_21# sky130_fd_sc_hd__dfrtp_1_5/a_1217_47# SUB sky130_fd_pr__nfet_01v8 ad=0 pd=0 as=0 ps=0 w=84 l=30
X243 sky130_fd_sc_hd__dfrtp_1_5/a_651_413# sky130_fd_sc_hd__inv_2_0/Y SUB SUB sky130_fd_pr__pfet_01v8_hvt ad=0 pd=0 as=0 ps=0 w=84 l=30
X244 SUB sky130_fd_sc_hd__clkbuf_2_1/X sky130_fd_sc_hd__dfrtp_1_5/a_27_47# SUB sky130_fd_pr__nfet_01v8 ad=0 pd=0 as=4.368n ps=0.272m w=84 l=30
X245 sky130_fd_sc_hd__dfrtp_1_5/a_761_289# sky130_fd_sc_hd__dfrtp_1_5/a_543_47# SUB SUB sky130_fd_pr__pfet_01v8_hvt ad=0 pd=0 as=0 ps=0 w=168 l=30
X246 SUB SUB sky130_fd_sc_hd__clkbuf_4_3/a_27_47# SUB sky130_fd_pr__pfet_01v8_hvt ad=0 pd=0 as=10.6n ps=0.506m w=200 l=30
X247 SUB sky130_fd_sc_hd__clkbuf_4_3/a_27_47# count[6] SUB sky130_fd_pr__nfet_01v8 ad=0 pd=0 as=9.408n ps=0.56m w=84 l=30
X248 SUB sky130_fd_sc_hd__clkbuf_4_3/a_27_47# count[6] SUB sky130_fd_pr__nfet_01v8 ad=0 pd=0 as=0 ps=0 w=84 l=30
X249 count[6] sky130_fd_sc_hd__clkbuf_4_3/a_27_47# SUB SUB sky130_fd_pr__pfet_01v8_hvt ad=22.4n pd=1.024m as=0 ps=0 w=200 l=30
X250 count[6] sky130_fd_sc_hd__clkbuf_4_3/a_27_47# SUB SUB sky130_fd_pr__nfet_01v8 ad=0 pd=0 as=0 ps=0 w=84 l=30
X251 SUB SUB sky130_fd_sc_hd__clkbuf_4_3/a_27_47# SUB sky130_fd_pr__nfet_01v8 ad=0 pd=0 as=4.452n ps=0.274m w=84 l=30
X252 SUB sky130_fd_sc_hd__clkbuf_4_3/a_27_47# count[6] SUB sky130_fd_pr__pfet_01v8_hvt ad=0 pd=0 as=0 ps=0 w=200 l=30
X253 count[6] sky130_fd_sc_hd__clkbuf_4_3/a_27_47# SUB SUB sky130_fd_pr__nfet_01v8 ad=0 pd=0 as=0 ps=0 w=84 l=30
X254 count[6] sky130_fd_sc_hd__clkbuf_4_3/a_27_47# SUB SUB sky130_fd_pr__pfet_01v8_hvt ad=0 pd=0 as=0 ps=0 w=200 l=30
X255 SUB sky130_fd_sc_hd__clkbuf_4_3/a_27_47# count[6] SUB sky130_fd_pr__pfet_01v8_hvt ad=0 pd=0 as=0 ps=0 w=200 l=30
X256 SUB sky130_fd_sc_hd__clkbuf_2_2/X sky130_fd_sc_hd__clkbuf_2_0/a_27_47# SUB sky130_fd_pr__pfet_01v8_hvt ad=6.5n pd=0.265m as=10.6n ps=0.506m w=200 l=30
X257 SUB sky130_fd_sc_hd__clkbuf_2_0/a_27_47# SUB SUB sky130_fd_pr__pfet_01v8_hvt ad=10.4n pd=0.504m as=5.4n ps=0.254m w=200 l=30
X258 SUB sky130_fd_sc_hd__clkbuf_2_2/X sky130_fd_sc_hd__clkbuf_2_0/a_27_47# SUB sky130_fd_pr__nfet_01v8 ad=2.73n pd=0.149m as=4.452n ps=0.274m w=84 l=30
X259 SUB sky130_fd_sc_hd__clkbuf_2_0/a_27_47# SUB SUB sky130_fd_pr__pfet_01v8_hvt ad=5.4n pd=0.254m as=6.5n ps=0.265m w=200 l=30
X260 SUB sky130_fd_sc_hd__clkbuf_2_0/a_27_47# SUB SUB sky130_fd_pr__nfet_01v8 ad=2.268n pd=0.138m as=2.73n ps=0.149m w=84 l=30
X261 SUB sky130_fd_sc_hd__clkbuf_2_0/a_27_47# SUB SUB sky130_fd_pr__nfet_01v8 ad=4.368n pd=0.272m as=2.268n ps=0.138m w=84 l=30
X262 SUB sky130_fd_sc_hd__buf_4_0/a_27_47# count[7] SUB sky130_fd_pr__pfet_01v8_hvt ad=10.4n pd=0.504m as=5.4n ps=0.254m w=200 l=30
X263 count[7] sky130_fd_sc_hd__buf_4_0/a_27_47# SUB SUB sky130_fd_pr__pfet_01v8_hvt ad=5.4n pd=0.254m as=5.4n ps=0.254m w=200 l=30
X264 SUB sky130_fd_sc_hd__buf_4_0/a_27_47# count[7] SUB sky130_fd_pr__pfet_01v8_hvt ad=5.4n pd=0.254m as=5.4n ps=0.254m w=200 l=30
X265 count[7] sky130_fd_sc_hd__buf_4_0/a_27_47# SUB SUB sky130_fd_pr__pfet_01v8_hvt ad=5.4n pd=0.254m as=5.4n ps=0.254m w=200 l=30
X266 count[7] sky130_fd_sc_hd__buf_4_0/a_27_47# SUB SUB sky130_fd_pr__nfet_01v8 ad=3.51n pd=0.184m as=3.51n ps=0.184m w=130 l=30
X267 count[7] sky130_fd_sc_hd__buf_4_0/a_27_47# SUB SUB sky130_fd_pr__nfet_01v8 ad=3.51n pd=0.184m as=3.51n ps=0.184m w=130 l=30
X268 SUB sky130_fd_sc_hd__buf_4_0/a_27_47# count[7] SUB sky130_fd_pr__nfet_01v8 ad=3.51n pd=0.184m as=3.51n ps=0.184m w=130 l=30
X269 SUB sky130_fd_sc_hd__buf_4_0/a_27_47# count[7] SUB sky130_fd_pr__nfet_01v8 ad=6.76n pd=0.364m as=3.51n ps=0.184m w=130 l=30
X270 SUB sky130_fd_sc_hd__buf_4_0/A sky130_fd_sc_hd__buf_4_0/a_27_47# SUB sky130_fd_pr__pfet_01v8_hvt ad=5.4n pd=0.254m as=10.4n ps=0.504m w=200 l=30
X271 SUB sky130_fd_sc_hd__buf_4_0/A sky130_fd_sc_hd__buf_4_0/a_27_47# SUB sky130_fd_pr__nfet_01v8 ad=3.51n pd=0.184m as=6.76n ps=0.364m w=130 l=30
X272 sky130_fd_sc_hd__dfrtp_1_6/a_1217_47# sky130_fd_sc_hd__dfrtp_1_6/a_27_47# sky130_fd_sc_hd__dfrtp_1_6/a_1108_47# SUB sky130_fd_pr__nfet_01v8 ad=5.352n pd=0.3m as=5.688n ps=0.302m w=72 l=30
X273 sky130_fd_sc_hd__dfrtp_1_6/a_805_47# sky130_fd_sc_hd__dfrtp_1_6/a_761_289# sky130_fd_sc_hd__dfrtp_1_6/a_639_47# SUB sky130_fd_pr__nfet_01v8 ad=3.528n pd=0.252m as=11.208n ps=0.44m w=84 l=30
X274 sky130_fd_sc_hd__dfrtp_1_6/a_1108_47# sky130_fd_sc_hd__dfrtp_1_6/a_193_47# sky130_fd_sc_hd__dfrtp_1_6/a_761_289# SUB sky130_fd_pr__nfet_01v8 ad=0 pd=0 as=7.992n ps=0.394m w=72 l=30
X275 sky130_fd_sc_hd__dfrtp_1_6/a_1283_21# sky130_fd_sc_hd__dfrtp_1_6/a_1108_47# sky130_fd_sc_hd__dfrtp_1_6/a_1462_47# SUB sky130_fd_pr__nfet_01v8 ad=4.368n pd=0.272m as=5.124n ps=0.29m w=84 l=30
X276 sky130_fd_sc_hd__dfrtp_1_6/a_651_413# sky130_fd_sc_hd__dfrtp_1_6/a_27_47# sky130_fd_sc_hd__dfrtp_1_6/a_543_47# SUB sky130_fd_pr__pfet_01v8_hvt ad=13.608n pd=0.66m as=5.796n ps=0.306m w=84 l=30
X277 SUB sky130_fd_sc_hd__inv_2_0/Y sky130_fd_sc_hd__dfrtp_1_6/a_805_47# SUB sky130_fd_pr__nfet_01v8 ad=0 pd=0 as=0 ps=0 w=84 l=30
X278 SUB sky130_fd_sc_hd__dfrtp_1_6/a_1283_21# SUB SUB sky130_fd_pr__pfet_01v8_hvt ad=0 pd=0 as=0 ps=0 w=200 l=30
X279 SUB SUB sky130_fd_sc_hd__dfrtp_1_6/a_27_47# SUB sky130_fd_pr__pfet_01v8_hvt ad=0 pd=0 as=6.656n ps=0.36m w=128 l=30
X280 sky130_fd_sc_hd__dfrtp_1_6/a_448_47# sky130_fd_sc_hd__xor2_1_2/X SUB SUB sky130_fd_pr__pfet_01v8_hvt ad=5.208n pd=0.292m as=0 ps=0 w=84 l=30
X281 sky130_fd_sc_hd__dfrtp_1_6/a_761_289# sky130_fd_sc_hd__dfrtp_1_6/a_543_47# SUB SUB sky130_fd_pr__nfet_01v8 ad=0 pd=0 as=0 ps=0 w=128 l=30
X282 sky130_fd_sc_hd__dfrtp_1_6/a_193_47# sky130_fd_sc_hd__dfrtp_1_6/a_27_47# SUB SUB sky130_fd_pr__nfet_01v8 ad=4.368n pd=0.272m as=0 ps=0 w=84 l=30
X283 sky130_fd_sc_hd__dfrtp_1_6/a_1108_47# sky130_fd_sc_hd__dfrtp_1_6/a_27_47# sky130_fd_sc_hd__dfrtp_1_6/a_761_289# SUB sky130_fd_pr__pfet_01v8_hvt ad=4.704n pd=0.28m as=10.332n ps=0.474m w=84 l=30
X284 sky130_fd_sc_hd__dfrtp_1_6/a_543_47# sky130_fd_sc_hd__dfrtp_1_6/a_27_47# sky130_fd_sc_hd__dfrtp_1_6/a_448_47# SUB sky130_fd_pr__nfet_01v8 ad=4.752n pd=0.276m as=5.28n ps=0.298m w=72 l=30
X285 sky130_fd_sc_hd__dfrtp_1_6/a_1462_47# sky130_fd_sc_hd__inv_2_0/Y SUB SUB sky130_fd_pr__nfet_01v8 ad=0 pd=0 as=0 ps=0 w=84 l=30
X286 sky130_fd_sc_hd__dfrtp_1_6/a_543_47# sky130_fd_sc_hd__dfrtp_1_6/a_193_47# sky130_fd_sc_hd__dfrtp_1_6/a_448_47# SUB sky130_fd_pr__pfet_01v8_hvt ad=0 pd=0 as=0 ps=0 w=84 l=30
X287 sky130_fd_sc_hd__dfrtp_1_6/a_448_47# sky130_fd_sc_hd__xor2_1_2/X SUB SUB sky130_fd_pr__nfet_01v8 ad=0 pd=0 as=0 ps=0 w=84 l=30
X288 SUB sky130_fd_sc_hd__dfrtp_1_6/a_1283_21# sky130_fd_sc_hd__dfrtp_1_6/a_1270_413# SUB sky130_fd_pr__pfet_01v8_hvt ad=0 pd=0 as=4.536n ps=0.276m w=84 l=30
X289 SUB sky130_fd_sc_hd__dfrtp_1_6/a_1108_47# sky130_fd_sc_hd__dfrtp_1_6/a_1283_21# SUB sky130_fd_pr__pfet_01v8_hvt ad=0 pd=0 as=4.536n ps=0.276m w=84 l=30
X290 sky130_fd_sc_hd__dfrtp_1_6/a_1270_413# sky130_fd_sc_hd__dfrtp_1_6/a_193_47# sky130_fd_sc_hd__dfrtp_1_6/a_1108_47# SUB sky130_fd_pr__pfet_01v8_hvt ad=0 pd=0 as=0 ps=0 w=84 l=30
X291 sky130_fd_sc_hd__dfrtp_1_6/a_193_47# sky130_fd_sc_hd__dfrtp_1_6/a_27_47# SUB SUB sky130_fd_pr__pfet_01v8_hvt ad=6.656n pd=0.36m as=0 ps=0 w=128 l=30
X292 sky130_fd_sc_hd__dfrtp_1_6/a_1283_21# sky130_fd_sc_hd__inv_2_0/Y SUB SUB sky130_fd_pr__pfet_01v8_hvt ad=0 pd=0 as=0 ps=0 w=84 l=30
X293 SUB sky130_fd_sc_hd__dfrtp_1_6/a_761_289# sky130_fd_sc_hd__dfrtp_1_6/a_651_413# SUB sky130_fd_pr__pfet_01v8_hvt ad=0 pd=0 as=0 ps=0 w=84 l=30
X294 SUB sky130_fd_sc_hd__dfrtp_1_6/a_1283_21# SUB SUB sky130_fd_pr__nfet_01v8 ad=0 pd=0 as=0 ps=0 w=130 l=30
X295 sky130_fd_sc_hd__dfrtp_1_6/a_639_47# sky130_fd_sc_hd__dfrtp_1_6/a_193_47# sky130_fd_sc_hd__dfrtp_1_6/a_543_47# SUB sky130_fd_pr__nfet_01v8 ad=0 pd=0 as=0 ps=0 w=72 l=30
X296 SUB sky130_fd_sc_hd__dfrtp_1_6/a_1283_21# sky130_fd_sc_hd__dfrtp_1_6/a_1217_47# SUB sky130_fd_pr__nfet_01v8 ad=0 pd=0 as=0 ps=0 w=84 l=30
X297 sky130_fd_sc_hd__dfrtp_1_6/a_651_413# sky130_fd_sc_hd__inv_2_0/Y SUB SUB sky130_fd_pr__pfet_01v8_hvt ad=0 pd=0 as=0 ps=0 w=84 l=30
X298 SUB SUB sky130_fd_sc_hd__dfrtp_1_6/a_27_47# SUB sky130_fd_pr__nfet_01v8 ad=0 pd=0 as=4.368n ps=0.272m w=84 l=30
X299 sky130_fd_sc_hd__dfrtp_1_6/a_761_289# sky130_fd_sc_hd__dfrtp_1_6/a_543_47# SUB SUB sky130_fd_pr__pfet_01v8_hvt ad=0 pd=0 as=0 ps=0 w=168 l=30
X300 SUB sky130_fd_sc_hd__clkbuf_2_2/X sky130_fd_sc_hd__clkbuf_2_1/a_27_47# SUB sky130_fd_pr__pfet_01v8_hvt ad=0 pd=0 as=10.6n ps=0.506m w=200 l=30
X301 SUB sky130_fd_sc_hd__clkbuf_2_1/a_27_47# sky130_fd_sc_hd__clkbuf_2_1/X SUB sky130_fd_pr__pfet_01v8_hvt ad=0 pd=0 as=10.8n ps=0.508m w=200 l=30
X302 SUB sky130_fd_sc_hd__clkbuf_2_2/X sky130_fd_sc_hd__clkbuf_2_1/a_27_47# SUB sky130_fd_pr__nfet_01v8 ad=0 pd=0 as=4.452n ps=0.274m w=84 l=30
X303 sky130_fd_sc_hd__clkbuf_2_1/X sky130_fd_sc_hd__clkbuf_2_1/a_27_47# SUB SUB sky130_fd_pr__pfet_01v8_hvt ad=0 pd=0 as=0 ps=0 w=200 l=30
X304 sky130_fd_sc_hd__clkbuf_2_1/X sky130_fd_sc_hd__clkbuf_2_1/a_27_47# SUB SUB sky130_fd_pr__nfet_01v8 ad=4.536n pd=0.276m as=0 ps=0 w=84 l=30
X305 SUB sky130_fd_sc_hd__clkbuf_2_1/a_27_47# sky130_fd_sc_hd__clkbuf_2_1/X SUB sky130_fd_pr__nfet_01v8 ad=0 pd=0 as=0 ps=0 w=84 l=30
X306 SUB sky130_fd_sc_hd__buf_4_1/a_27_47# count[4] SUB sky130_fd_pr__pfet_01v8_hvt ad=0 pd=0 as=21.6n ps=1.016m w=200 l=30
X307 count[4] sky130_fd_sc_hd__buf_4_1/a_27_47# SUB SUB sky130_fd_pr__pfet_01v8_hvt ad=0 pd=0 as=0 ps=0 w=200 l=30
X308 SUB sky130_fd_sc_hd__buf_4_1/a_27_47# count[4] SUB sky130_fd_pr__pfet_01v8_hvt ad=0 pd=0 as=0 ps=0 w=200 l=30
X309 count[4] sky130_fd_sc_hd__buf_4_1/a_27_47# SUB SUB sky130_fd_pr__pfet_01v8_hvt ad=0 pd=0 as=0 ps=0 w=200 l=30
X310 count[4] sky130_fd_sc_hd__buf_4_1/a_27_47# SUB SUB sky130_fd_pr__nfet_01v8 ad=14.04n pd=0.736m as=0 ps=0 w=130 l=30
X311 count[4] sky130_fd_sc_hd__buf_4_1/a_27_47# SUB SUB sky130_fd_pr__nfet_01v8 ad=0 pd=0 as=0 ps=0 w=130 l=30
X312 SUB sky130_fd_sc_hd__buf_4_1/a_27_47# count[4] SUB sky130_fd_pr__nfet_01v8 ad=0 pd=0 as=0 ps=0 w=130 l=30
X313 SUB sky130_fd_sc_hd__buf_4_1/a_27_47# count[4] SUB sky130_fd_pr__nfet_01v8 ad=0 pd=0 as=0 ps=0 w=130 l=30
X314 SUB sky130_fd_sc_hd__buf_4_1/A sky130_fd_sc_hd__buf_4_1/a_27_47# SUB sky130_fd_pr__pfet_01v8_hvt ad=0 pd=0 as=10.4n ps=0.504m w=200 l=30
X315 SUB sky130_fd_sc_hd__buf_4_1/A sky130_fd_sc_hd__buf_4_1/a_27_47# SUB sky130_fd_pr__nfet_01v8 ad=0 pd=0 as=6.76n ps=0.364m w=130 l=30
X316 sky130_fd_sc_hd__dfrtp_1_7/a_1217_47# sky130_fd_sc_hd__dfrtp_1_7/a_27_47# sky130_fd_sc_hd__dfrtp_1_7/a_1108_47# SUB sky130_fd_pr__nfet_01v8 ad=5.352n pd=0.3m as=5.688n ps=0.302m w=72 l=30
X317 sky130_fd_sc_hd__dfrtp_1_7/a_805_47# sky130_fd_sc_hd__dfrtp_1_7/a_761_289# sky130_fd_sc_hd__dfrtp_1_7/a_639_47# SUB sky130_fd_pr__nfet_01v8 ad=3.528n pd=0.252m as=11.208n ps=0.44m w=84 l=30
X318 sky130_fd_sc_hd__dfrtp_1_7/a_1108_47# sky130_fd_sc_hd__dfrtp_1_7/a_193_47# sky130_fd_sc_hd__dfrtp_1_7/a_761_289# SUB sky130_fd_pr__nfet_01v8 ad=0 pd=0 as=7.992n ps=0.394m w=72 l=30
X319 sky130_fd_sc_hd__dfrtp_1_7/a_1283_21# sky130_fd_sc_hd__dfrtp_1_7/a_1108_47# sky130_fd_sc_hd__dfrtp_1_7/a_1462_47# SUB sky130_fd_pr__nfet_01v8 ad=4.368n pd=0.272m as=5.124n ps=0.29m w=84 l=30
X320 sky130_fd_sc_hd__dfrtp_1_7/a_651_413# sky130_fd_sc_hd__dfrtp_1_7/a_27_47# sky130_fd_sc_hd__dfrtp_1_7/a_543_47# SUB sky130_fd_pr__pfet_01v8_hvt ad=13.608n pd=0.66m as=5.796n ps=0.306m w=84 l=30
X321 SUB sky130_fd_sc_hd__inv_2_0/Y sky130_fd_sc_hd__dfrtp_1_7/a_805_47# SUB sky130_fd_pr__nfet_01v8 ad=0 pd=0 as=0 ps=0 w=84 l=30
X322 sky130_fd_sc_hd__buf_4_2/A sky130_fd_sc_hd__dfrtp_1_7/a_1283_21# SUB SUB sky130_fd_pr__pfet_01v8_hvt ad=10.4n pd=0.504m as=0 ps=0 w=200 l=30
X323 SUB sky130_fd_sc_hd__clkbuf_2_1/X sky130_fd_sc_hd__dfrtp_1_7/a_27_47# SUB sky130_fd_pr__pfet_01v8_hvt ad=0 pd=0 as=6.656n ps=0.36m w=128 l=30
X324 sky130_fd_sc_hd__dfrtp_1_7/a_448_47# sky130_fd_sc_hd__xnor2_1_1/Y SUB SUB sky130_fd_pr__pfet_01v8_hvt ad=5.208n pd=0.292m as=0 ps=0 w=84 l=30
X325 sky130_fd_sc_hd__dfrtp_1_7/a_761_289# sky130_fd_sc_hd__dfrtp_1_7/a_543_47# SUB SUB sky130_fd_pr__nfet_01v8 ad=0 pd=0 as=0 ps=0 w=128 l=30
X326 sky130_fd_sc_hd__dfrtp_1_7/a_193_47# sky130_fd_sc_hd__dfrtp_1_7/a_27_47# SUB SUB sky130_fd_pr__nfet_01v8 ad=4.368n pd=0.272m as=0 ps=0 w=84 l=30
X327 sky130_fd_sc_hd__dfrtp_1_7/a_1108_47# sky130_fd_sc_hd__dfrtp_1_7/a_27_47# sky130_fd_sc_hd__dfrtp_1_7/a_761_289# SUB sky130_fd_pr__pfet_01v8_hvt ad=4.704n pd=0.28m as=10.332n ps=0.474m w=84 l=30
X328 sky130_fd_sc_hd__dfrtp_1_7/a_543_47# sky130_fd_sc_hd__dfrtp_1_7/a_27_47# sky130_fd_sc_hd__dfrtp_1_7/a_448_47# SUB sky130_fd_pr__nfet_01v8 ad=4.752n pd=0.276m as=5.28n ps=0.298m w=72 l=30
X329 sky130_fd_sc_hd__dfrtp_1_7/a_1462_47# sky130_fd_sc_hd__inv_2_0/Y SUB SUB sky130_fd_pr__nfet_01v8 ad=0 pd=0 as=0 ps=0 w=84 l=30
X330 sky130_fd_sc_hd__dfrtp_1_7/a_543_47# sky130_fd_sc_hd__dfrtp_1_7/a_193_47# sky130_fd_sc_hd__dfrtp_1_7/a_448_47# SUB sky130_fd_pr__pfet_01v8_hvt ad=0 pd=0 as=0 ps=0 w=84 l=30
X331 sky130_fd_sc_hd__dfrtp_1_7/a_448_47# sky130_fd_sc_hd__xnor2_1_1/Y SUB SUB sky130_fd_pr__nfet_01v8 ad=0 pd=0 as=0 ps=0 w=84 l=30
X332 SUB sky130_fd_sc_hd__dfrtp_1_7/a_1283_21# sky130_fd_sc_hd__dfrtp_1_7/a_1270_413# SUB sky130_fd_pr__pfet_01v8_hvt ad=0 pd=0 as=4.536n ps=0.276m w=84 l=30
X333 SUB sky130_fd_sc_hd__dfrtp_1_7/a_1108_47# sky130_fd_sc_hd__dfrtp_1_7/a_1283_21# SUB sky130_fd_pr__pfet_01v8_hvt ad=0 pd=0 as=4.536n ps=0.276m w=84 l=30
X334 sky130_fd_sc_hd__dfrtp_1_7/a_1270_413# sky130_fd_sc_hd__dfrtp_1_7/a_193_47# sky130_fd_sc_hd__dfrtp_1_7/a_1108_47# SUB sky130_fd_pr__pfet_01v8_hvt ad=0 pd=0 as=0 ps=0 w=84 l=30
X335 sky130_fd_sc_hd__dfrtp_1_7/a_193_47# sky130_fd_sc_hd__dfrtp_1_7/a_27_47# SUB SUB sky130_fd_pr__pfet_01v8_hvt ad=6.656n pd=0.36m as=0 ps=0 w=128 l=30
X336 sky130_fd_sc_hd__dfrtp_1_7/a_1283_21# sky130_fd_sc_hd__inv_2_0/Y SUB SUB sky130_fd_pr__pfet_01v8_hvt ad=0 pd=0 as=0 ps=0 w=84 l=30
X337 SUB sky130_fd_sc_hd__dfrtp_1_7/a_761_289# sky130_fd_sc_hd__dfrtp_1_7/a_651_413# SUB sky130_fd_pr__pfet_01v8_hvt ad=0 pd=0 as=0 ps=0 w=84 l=30
X338 sky130_fd_sc_hd__buf_4_2/A sky130_fd_sc_hd__dfrtp_1_7/a_1283_21# SUB SUB sky130_fd_pr__nfet_01v8 ad=6.76n pd=0.364m as=0 ps=0 w=130 l=30
X339 sky130_fd_sc_hd__dfrtp_1_7/a_639_47# sky130_fd_sc_hd__dfrtp_1_7/a_193_47# sky130_fd_sc_hd__dfrtp_1_7/a_543_47# SUB sky130_fd_pr__nfet_01v8 ad=0 pd=0 as=0 ps=0 w=72 l=30
X340 SUB sky130_fd_sc_hd__dfrtp_1_7/a_1283_21# sky130_fd_sc_hd__dfrtp_1_7/a_1217_47# SUB sky130_fd_pr__nfet_01v8 ad=0 pd=0 as=0 ps=0 w=84 l=30
X341 sky130_fd_sc_hd__dfrtp_1_7/a_651_413# sky130_fd_sc_hd__inv_2_0/Y SUB SUB sky130_fd_pr__pfet_01v8_hvt ad=0 pd=0 as=0 ps=0 w=84 l=30
X342 SUB sky130_fd_sc_hd__clkbuf_2_1/X sky130_fd_sc_hd__dfrtp_1_7/a_27_47# SUB sky130_fd_pr__nfet_01v8 ad=0 pd=0 as=4.368n ps=0.272m w=84 l=30
X343 sky130_fd_sc_hd__dfrtp_1_7/a_761_289# sky130_fd_sc_hd__dfrtp_1_7/a_543_47# SUB SUB sky130_fd_pr__pfet_01v8_hvt ad=0 pd=0 as=0 ps=0 w=168 l=30
X344 SUB clk sky130_fd_sc_hd__clkbuf_2_2/a_27_47# SUB sky130_fd_pr__pfet_01v8_hvt ad=0 pd=0 as=10.6n ps=0.506m w=200 l=30
X345 SUB sky130_fd_sc_hd__clkbuf_2_2/a_27_47# sky130_fd_sc_hd__clkbuf_2_2/X SUB sky130_fd_pr__pfet_01v8_hvt ad=0 pd=0 as=10.8n ps=0.508m w=200 l=30
X346 SUB clk sky130_fd_sc_hd__clkbuf_2_2/a_27_47# SUB sky130_fd_pr__nfet_01v8 ad=0 pd=0 as=4.452n ps=0.274m w=84 l=30
X347 sky130_fd_sc_hd__clkbuf_2_2/X sky130_fd_sc_hd__clkbuf_2_2/a_27_47# SUB SUB sky130_fd_pr__pfet_01v8_hvt ad=0 pd=0 as=0 ps=0 w=200 l=30
X348 sky130_fd_sc_hd__clkbuf_2_2/X sky130_fd_sc_hd__clkbuf_2_2/a_27_47# SUB SUB sky130_fd_pr__nfet_01v8 ad=4.536n pd=0.276m as=0 ps=0 w=84 l=30
X349 SUB sky130_fd_sc_hd__clkbuf_2_2/a_27_47# sky130_fd_sc_hd__clkbuf_2_2/X SUB sky130_fd_pr__nfet_01v8 ad=0 pd=0 as=0 ps=0 w=84 l=30
X350 SUB sky130_fd_sc_hd__buf_4_2/a_27_47# count[5] SUB sky130_fd_pr__pfet_01v8_hvt ad=0 pd=0 as=21.6n ps=1.016m w=200 l=30
X351 count[5] sky130_fd_sc_hd__buf_4_2/a_27_47# SUB SUB sky130_fd_pr__pfet_01v8_hvt ad=0 pd=0 as=0 ps=0 w=200 l=30
X352 SUB sky130_fd_sc_hd__buf_4_2/a_27_47# count[5] SUB sky130_fd_pr__pfet_01v8_hvt ad=0 pd=0 as=0 ps=0 w=200 l=30
X353 count[5] sky130_fd_sc_hd__buf_4_2/a_27_47# SUB SUB sky130_fd_pr__pfet_01v8_hvt ad=0 pd=0 as=0 ps=0 w=200 l=30
X354 count[5] sky130_fd_sc_hd__buf_4_2/a_27_47# SUB SUB sky130_fd_pr__nfet_01v8 ad=14.04n pd=0.736m as=0 ps=0 w=130 l=30
X355 count[5] sky130_fd_sc_hd__buf_4_2/a_27_47# SUB SUB sky130_fd_pr__nfet_01v8 ad=0 pd=0 as=0 ps=0 w=130 l=30
X356 SUB sky130_fd_sc_hd__buf_4_2/a_27_47# count[5] SUB sky130_fd_pr__nfet_01v8 ad=0 pd=0 as=0 ps=0 w=130 l=30
X357 SUB sky130_fd_sc_hd__buf_4_2/a_27_47# count[5] SUB sky130_fd_pr__nfet_01v8 ad=0 pd=0 as=0 ps=0 w=130 l=30
X358 SUB sky130_fd_sc_hd__buf_4_2/A sky130_fd_sc_hd__buf_4_2/a_27_47# SUB sky130_fd_pr__pfet_01v8_hvt ad=0 pd=0 as=10.4n ps=0.504m w=200 l=30
X359 SUB sky130_fd_sc_hd__buf_4_2/A sky130_fd_sc_hd__buf_4_2/a_27_47# SUB sky130_fd_pr__nfet_01v8 ad=0 pd=0 as=6.76n ps=0.364m w=130 l=30
X360 SUB sky130_fd_sc_hd__buf_4_3/a_27_47# count[2] SUB sky130_fd_pr__pfet_01v8_hvt ad=0 pd=0 as=21.6n ps=1.016m w=200 l=30
X361 count[2] sky130_fd_sc_hd__buf_4_3/a_27_47# SUB SUB sky130_fd_pr__pfet_01v8_hvt ad=0 pd=0 as=0 ps=0 w=200 l=30
X362 SUB sky130_fd_sc_hd__buf_4_3/a_27_47# count[2] SUB sky130_fd_pr__pfet_01v8_hvt ad=0 pd=0 as=0 ps=0 w=200 l=30
X363 count[2] sky130_fd_sc_hd__buf_4_3/a_27_47# SUB SUB sky130_fd_pr__pfet_01v8_hvt ad=0 pd=0 as=0 ps=0 w=200 l=30
X364 count[2] sky130_fd_sc_hd__buf_4_3/a_27_47# SUB SUB sky130_fd_pr__nfet_01v8 ad=14.04n pd=0.736m as=0 ps=0 w=130 l=30
X365 count[2] sky130_fd_sc_hd__buf_4_3/a_27_47# SUB SUB sky130_fd_pr__nfet_01v8 ad=0 pd=0 as=0 ps=0 w=130 l=30
X366 SUB sky130_fd_sc_hd__buf_4_3/a_27_47# count[2] SUB sky130_fd_pr__nfet_01v8 ad=0 pd=0 as=0 ps=0 w=130 l=30
X367 SUB sky130_fd_sc_hd__buf_4_3/a_27_47# count[2] SUB sky130_fd_pr__nfet_01v8 ad=0 pd=0 as=0 ps=0 w=130 l=30
X368 SUB SUB sky130_fd_sc_hd__buf_4_3/a_27_47# SUB sky130_fd_pr__pfet_01v8_hvt ad=0 pd=0 as=10.4n ps=0.504m w=200 l=30
X369 SUB SUB sky130_fd_sc_hd__buf_4_3/a_27_47# SUB sky130_fd_pr__nfet_01v8 ad=0 pd=0 as=6.76n ps=0.364m w=130 l=30
X370 sky130_fd_sc_hd__inv_2_0/Y sky130_fd_sc_hd__inv_2_0/A SUB SUB sky130_fd_pr__pfet_01v8_hvt ad=5.4n pd=0.254m as=10.4n ps=0.504m w=200 l=30
X371 SUB sky130_fd_sc_hd__inv_2_0/A sky130_fd_sc_hd__inv_2_0/Y SUB sky130_fd_pr__nfet_01v8 ad=6.76n pd=0.364m as=3.51n ps=0.184m w=130 l=30
X372 sky130_fd_sc_hd__inv_2_0/Y sky130_fd_sc_hd__inv_2_0/A SUB SUB sky130_fd_pr__nfet_01v8 ad=3.51n pd=0.184m as=6.76n ps=0.364m w=130 l=30
X373 SUB sky130_fd_sc_hd__inv_2_0/A sky130_fd_sc_hd__inv_2_0/Y SUB sky130_fd_pr__pfet_01v8_hvt ad=10.4n pd=0.504m as=5.4n ps=0.254m w=200 l=30
X374 SUB SUB sky130_fd_sc_hd__xnor2_1_2/B SUB sky130_fd_pr__pfet_01v8_hvt ad=6.6n pd=0.266m as=5.4n ps=0.254m w=200 l=30
X375 sky130_fd_sc_hd__xnor2_1_2/B sky130_fd_sc_hd__ha_1_0/A SUB SUB sky130_fd_pr__pfet_01v8_hvt ad=10.4n pd=0.504m as=6.6n ps=0.266m w=200 l=30
X376 sky130_fd_sc_hd__nand3_1_0/a_193_47# SUB sky130_fd_sc_hd__nand3_1_0/a_109_47# SUB sky130_fd_pr__nfet_01v8 ad=4.29n pd=0.196m as=3.51n ps=0.184m w=130 l=30
X377 sky130_fd_sc_hd__xnor2_1_2/B sky130_fd_sc_hd__ha_1_0/A sky130_fd_sc_hd__nand3_1_0/a_193_47# SUB sky130_fd_pr__nfet_01v8 ad=6.76n pd=0.364m as=4.29n ps=0.196m w=130 l=30
X378 sky130_fd_sc_hd__xnor2_1_2/B sky130_fd_sc_hd__ha_1_0/B SUB SUB sky130_fd_pr__pfet_01v8_hvt ad=5.4n pd=0.254m as=10.4n ps=0.504m w=200 l=30
X379 sky130_fd_sc_hd__nand3_1_0/a_109_47# sky130_fd_sc_hd__ha_1_0/B SUB SUB sky130_fd_pr__nfet_01v8 ad=3.51n pd=0.184m as=6.76n ps=0.364m w=130 l=30
X380 SUB sky130_fd_sc_hd__xnor2_1_2/A sky130_fd_sc_hd__xnor2_1_1/B SUB sky130_fd_pr__pfet_01v8_hvt ad=0 pd=0 as=21.2n ps=1.012m w=200 l=30
X381 sky130_fd_sc_hd__xnor2_1_1/B SUB SUB SUB sky130_fd_pr__pfet_01v8_hvt ad=0 pd=0 as=0 ps=0 w=200 l=30
X382 sky130_fd_sc_hd__nand3_1_1/a_193_47# sky130_fd_sc_hd__xnor2_1_2/A sky130_fd_sc_hd__nand3_1_1/a_109_47# SUB sky130_fd_pr__nfet_01v8 ad=8.58n pd=0.392m as=7.02n ps=0.368m w=130 l=30
X383 sky130_fd_sc_hd__xnor2_1_1/B SUB sky130_fd_sc_hd__nand3_1_1/a_193_47# SUB sky130_fd_pr__nfet_01v8 ad=6.76n pd=0.364m as=0 ps=0 w=130 l=30
X384 sky130_fd_sc_hd__xnor2_1_1/B sky130_fd_sc_hd__and3_1_0/X SUB SUB sky130_fd_pr__pfet_01v8_hvt ad=0 pd=0 as=0 ps=0 w=200 l=30
X385 sky130_fd_sc_hd__nand3_1_1/a_109_47# sky130_fd_sc_hd__and3_1_0/X SUB SUB sky130_fd_pr__nfet_01v8 ad=0 pd=0 as=0 ps=0 w=130 l=30
X386 SUB sky130_fd_sc_hd__xnor2_1_2/A sky130_fd_sc_hd__nor3_1_0/C SUB sky130_fd_pr__pfet_01v8_hvt ad=0 pd=0 as=21.2n ps=1.012m w=200 l=30
X387 sky130_fd_sc_hd__nor3_1_0/C SUB SUB SUB sky130_fd_pr__pfet_01v8_hvt ad=0 pd=0 as=0 ps=0 w=200 l=30
X388 sky130_fd_sc_hd__nand3_1_2/a_193_47# sky130_fd_sc_hd__xnor2_1_2/A sky130_fd_sc_hd__nand3_1_2/a_109_47# SUB sky130_fd_pr__nfet_01v8 ad=8.58n pd=0.392m as=7.02n ps=0.368m w=130 l=30
X389 sky130_fd_sc_hd__nor3_1_0/C SUB sky130_fd_sc_hd__nand3_1_2/a_193_47# SUB sky130_fd_pr__nfet_01v8 ad=6.76n pd=0.364m as=0 ps=0 w=130 l=30
X390 sky130_fd_sc_hd__nor3_1_0/C SUB SUB SUB sky130_fd_pr__pfet_01v8_hvt ad=0 pd=0 as=0 ps=0 w=200 l=30
X391 sky130_fd_sc_hd__nand3_1_2/a_109_47# SUB SUB SUB sky130_fd_pr__nfet_01v8 ad=0 pd=0 as=0 ps=0 w=130 l=30
X392 SUB sky130_fd_sc_hd__xor2_1_2/B sky130_fd_sc_hd__nor2_1_0/A SUB sky130_fd_pr__pfet_01v8_hvt ad=0 pd=0 as=21.2n ps=1.012m w=200 l=30
X393 sky130_fd_sc_hd__nor2_1_0/A SUB SUB SUB sky130_fd_pr__pfet_01v8_hvt ad=0 pd=0 as=0 ps=0 w=200 l=30
X394 sky130_fd_sc_hd__nand3_1_3/a_193_47# sky130_fd_sc_hd__xor2_1_2/B sky130_fd_sc_hd__nand3_1_3/a_109_47# SUB sky130_fd_pr__nfet_01v8 ad=8.58n pd=0.392m as=7.02n ps=0.368m w=130 l=30
X395 sky130_fd_sc_hd__nor2_1_0/A SUB sky130_fd_sc_hd__nand3_1_3/a_193_47# SUB sky130_fd_pr__nfet_01v8 ad=6.76n pd=0.364m as=0 ps=0 w=130 l=30
X396 sky130_fd_sc_hd__nor2_1_0/A sky130_fd_sc_hd__xnor2_1_2/A SUB SUB sky130_fd_pr__pfet_01v8_hvt ad=0 pd=0 as=0 ps=0 w=200 l=30
X397 sky130_fd_sc_hd__nand3_1_3/a_109_47# sky130_fd_sc_hd__xnor2_1_2/A SUB SUB sky130_fd_pr__nfet_01v8 ad=0 pd=0 as=0 ps=0 w=130 l=30
X398 SUB sky130_fd_sc_hd__ha_1_0/A sky130_fd_sc_hd__nor3_1_0/A SUB sky130_fd_pr__pfet_01v8_hvt ad=10.4n pd=0.504m as=5.4n ps=0.254m w=200 l=30
X399 sky130_fd_sc_hd__nor3_1_0/A sky130_fd_sc_hd__ha_1_0/A sky130_fd_sc_hd__nand2_1_0/a_113_47# SUB sky130_fd_pr__nfet_01v8 ad=6.76n pd=0.364m as=3.51n ps=0.184m w=130 l=30
X400 sky130_fd_sc_hd__nand2_1_0/a_113_47# sky130_fd_sc_hd__ha_1_0/B SUB SUB sky130_fd_pr__nfet_01v8 ad=3.51n pd=0.184m as=6.76n ps=0.364m w=130 l=30
X401 sky130_fd_sc_hd__nor3_1_0/A sky130_fd_sc_hd__ha_1_0/B SUB SUB sky130_fd_pr__pfet_01v8_hvt ad=5.4n pd=0.254m as=10.4n ps=0.504m w=200 l=30
X402 SUB sky130_fd_sc_hd__buf_4_1/A sky130_fd_sc_hd__nor3_1_0/B SUB sky130_fd_pr__pfet_01v8_hvt ad=0 pd=0 as=10.8n ps=0.508m w=200 l=30
X403 sky130_fd_sc_hd__nor3_1_0/B sky130_fd_sc_hd__buf_4_1/A sky130_fd_sc_hd__nand2_1_1/a_113_47# SUB sky130_fd_pr__nfet_01v8 ad=6.76n pd=0.364m as=7.02n ps=0.368m w=130 l=30
X404 sky130_fd_sc_hd__nand2_1_1/a_113_47# sky130_fd_sc_hd__buf_4_2/A SUB SUB sky130_fd_pr__nfet_01v8 ad=0 pd=0 as=0 ps=0 w=130 l=30
X405 sky130_fd_sc_hd__nor3_1_0/B sky130_fd_sc_hd__buf_4_2/A SUB SUB sky130_fd_pr__pfet_01v8_hvt ad=0 pd=0 as=0 ps=0 w=200 l=30
X406 SUB sky130_fd_sc_hd__clkbuf_1_0/a_75_212# sky130_fd_sc_hd__inv_2_0/A SUB sky130_fd_pr__pfet_01v8_hvt ad=4.582n pd=0.216m as=8.216n ps=0.42m w=158 l=30
X407 sky130_fd_sc_hd__clkbuf_1_0/a_75_212# reset SUB SUB sky130_fd_pr__nfet_01v8 ad=5.408n pd=0.312m as=3.016n ps=0.162m w=104 l=30
X408 sky130_fd_sc_hd__clkbuf_1_0/a_75_212# reset SUB SUB sky130_fd_pr__pfet_01v8_hvt ad=8.216n pd=0.42m as=4.582n ps=0.216m w=158 l=30
X409 SUB sky130_fd_sc_hd__clkbuf_1_0/a_75_212# sky130_fd_sc_hd__inv_2_0/A SUB sky130_fd_pr__nfet_01v8 ad=3.016n pd=0.162m as=5.408n ps=0.312m w=104 l=30
X410 SUB sky130_fd_sc_hd__nor3_1_0/A sky130_fd_sc_hd__nor3_1_0/a_193_297# SUB sky130_fd_pr__pfet_01v8_hvt ad=10.4n pd=0.504m as=5.4n ps=0.254m w=200 l=30
X411 sky130_fd_sc_hd__nor3_1_0/a_193_297# sky130_fd_sc_hd__nor3_1_0/B sky130_fd_sc_hd__nor3_1_0/a_109_297# SUB sky130_fd_pr__pfet_01v8_hvt ad=5.4n pd=0.254m as=5.4n ps=0.254m w=200 l=30
X412 sky130_fd_sc_hd__xor2_1_0/B sky130_fd_sc_hd__nor3_1_0/B SUB SUB sky130_fd_pr__nfet_01v8 ad=3.51n pd=0.184m as=3.51n ps=0.184m w=130 l=30
X413 SUB sky130_fd_sc_hd__nor3_1_0/A sky130_fd_sc_hd__xor2_1_0/B SUB sky130_fd_pr__nfet_01v8 ad=6.76n pd=0.364m as=3.51n ps=0.184m w=130 l=30
X414 sky130_fd_sc_hd__nor3_1_0/a_109_297# sky130_fd_sc_hd__nor3_1_0/C sky130_fd_sc_hd__xor2_1_0/B SUB sky130_fd_pr__pfet_01v8_hvt ad=5.4n pd=0.254m as=10.4n ps=0.504m w=200 l=30
X415 SUB sky130_fd_sc_hd__nor3_1_0/C sky130_fd_sc_hd__xor2_1_0/B SUB sky130_fd_pr__nfet_01v8 ad=3.51n pd=0.184m as=6.76n ps=0.364m w=130 l=30
X416 SUB sky130_fd_sc_hd__ha_1_0/A sky130_fd_sc_hd__and3_1_0/a_27_47# SUB sky130_fd_pr__pfet_01v8_hvt ad=2.268n pd=0.138m as=4.368n ps=0.272m w=84 l=30
X417 SUB sky130_fd_sc_hd__ha_1_0/B sky130_fd_sc_hd__and3_1_0/a_27_47# SUB sky130_fd_pr__pfet_01v8_hvt ad=5.689n pd=0.267m as=2.646n ps=0.147m w=84 l=30
X418 sky130_fd_sc_hd__and3_1_0/a_181_47# sky130_fd_sc_hd__buf_4_1/A sky130_fd_sc_hd__and3_1_0/a_109_47# SUB sky130_fd_pr__nfet_01v8 ad=1.764n pd=0.126m as=1.764n ps=0.126m w=84 l=30
X419 SUB sky130_fd_sc_hd__ha_1_0/B sky130_fd_sc_hd__and3_1_0/a_181_47# SUB sky130_fd_pr__nfet_01v8 ad=5.266n pd=0.228m as=1.764n ps=0.126m w=84 l=30
X420 sky130_fd_sc_hd__and3_1_0/a_27_47# sky130_fd_sc_hd__buf_4_1/A SUB SUB sky130_fd_pr__pfet_01v8_hvt ad=2.646n pd=0.147m as=2.268n ps=0.138m w=84 l=30
X421 sky130_fd_sc_hd__and3_1_0/X sky130_fd_sc_hd__and3_1_0/a_27_47# SUB SUB sky130_fd_pr__pfet_01v8_hvt ad=10.4n pd=0.504m as=5.689n ps=0.267m w=200 l=30
X422 sky130_fd_sc_hd__and3_1_0/X sky130_fd_sc_hd__and3_1_0/a_27_47# SUB SUB sky130_fd_pr__nfet_01v8 ad=6.76n pd=0.364m as=5.266n ps=0.228m w=130 l=30
X423 sky130_fd_sc_hd__and3_1_0/a_109_47# sky130_fd_sc_hd__ha_1_0/A sky130_fd_sc_hd__and3_1_0/a_27_47# SUB sky130_fd_pr__nfet_01v8 ad=1.764n pd=0.126m as=4.368n ps=0.272m w=84 l=30
X424 sky130_fd_sc_hd__inv_1_0/Y sky130_fd_sc_hd__ha_1_0/A SUB SUB sky130_fd_pr__nfet_01v8 ad=6.76n pd=0.364m as=6.76n ps=0.364m w=130 l=30
X425 sky130_fd_sc_hd__inv_1_0/Y sky130_fd_sc_hd__ha_1_0/A SUB SUB sky130_fd_pr__pfet_01v8_hvt ad=10.4n pd=0.504m as=10.4n ps=0.504m w=200 l=30
X426 sky130_fd_sc_hd__xor2_1_0/X sky130_fd_sc_hd__xor2_1_0/a_35_297# sky130_fd_sc_hd__xor2_1_0/a_285_297# SUB sky130_fd_pr__pfet_01v8_hvt ad=12n pd=0.52m as=10.4n ps=0.504m w=200 l=30
X427 sky130_fd_sc_hd__xor2_1_0/X sky130_fd_sc_hd__xor2_1_0/B sky130_fd_sc_hd__xor2_1_0/a_285_47# SUB sky130_fd_pr__nfet_01v8 ad=10.01n pd=0.284m as=3.51n ps=0.184m w=130 l=30
X428 sky130_fd_sc_hd__xor2_1_0/a_35_297# sky130_fd_sc_hd__xor2_1_0/B SUB SUB sky130_fd_pr__nfet_01v8 ad=3.51n pd=0.184m as=6.76n ps=0.364m w=130 l=30
X429 sky130_fd_sc_hd__xor2_1_0/a_117_297# sky130_fd_sc_hd__xor2_1_0/B sky130_fd_sc_hd__xor2_1_0/a_35_297# SUB sky130_fd_pr__pfet_01v8_hvt ad=5.4n pd=0.254m as=10.4n ps=0.504m w=200 l=30
X430 SUB sky130_fd_sc_hd__xor2_1_0/B sky130_fd_sc_hd__xor2_1_0/a_285_297# SUB sky130_fd_pr__pfet_01v8_hvt ad=10.4n pd=0.504m as=5.4n ps=0.254m w=200 l=30
X431 SUB sky130_fd_sc_hd__buf_4_0/A sky130_fd_sc_hd__xor2_1_0/a_35_297# SUB sky130_fd_pr__nfet_01v8 ad=3.51n pd=0.184m as=3.51n ps=0.184m w=130 l=30
X432 SUB sky130_fd_sc_hd__xor2_1_0/a_35_297# sky130_fd_sc_hd__xor2_1_0/X SUB sky130_fd_pr__nfet_01v8 ad=8.32n pd=0.388m as=10.01n ps=0.284m w=130 l=30
X433 sky130_fd_sc_hd__xor2_1_0/a_285_297# sky130_fd_sc_hd__buf_4_0/A SUB SUB sky130_fd_pr__pfet_01v8_hvt ad=5.4n pd=0.254m as=5.4n ps=0.254m w=200 l=30
X434 SUB sky130_fd_sc_hd__buf_4_0/A sky130_fd_sc_hd__xor2_1_0/a_117_297# SUB sky130_fd_pr__pfet_01v8_hvt ad=5.4n pd=0.254m as=5.4n ps=0.254m w=200 l=30
X435 sky130_fd_sc_hd__xor2_1_0/a_285_47# sky130_fd_sc_hd__buf_4_0/A SUB SUB sky130_fd_pr__nfet_01v8 ad=3.51n pd=0.184m as=3.51n ps=0.184m w=130 l=30
X436 sky130_fd_sc_hd__xor2_1_1/X sky130_fd_sc_hd__xor2_1_1/a_35_297# sky130_fd_sc_hd__xor2_1_1/a_285_297# SUB sky130_fd_pr__pfet_01v8_hvt ad=12n pd=0.52m as=21.2n ps=1.012m w=200 l=30
X437 sky130_fd_sc_hd__xor2_1_1/X sky130_fd_sc_hd__xor2_1_1/B sky130_fd_sc_hd__xor2_1_1/a_285_47# SUB sky130_fd_pr__nfet_01v8 ad=20.02n pd=0.568m as=7.02n ps=0.368m w=130 l=30
X438 sky130_fd_sc_hd__xor2_1_1/a_35_297# sky130_fd_sc_hd__xor2_1_1/B SUB SUB sky130_fd_pr__nfet_01v8 ad=7.02n pd=0.368m as=0 ps=0 w=130 l=30
X439 sky130_fd_sc_hd__xor2_1_1/a_117_297# sky130_fd_sc_hd__xor2_1_1/B sky130_fd_sc_hd__xor2_1_1/a_35_297# SUB sky130_fd_pr__pfet_01v8_hvt ad=10.8n pd=0.508m as=10.4n ps=0.504m w=200 l=30
X440 SUB sky130_fd_sc_hd__xor2_1_1/B sky130_fd_sc_hd__xor2_1_1/a_285_297# SUB sky130_fd_pr__pfet_01v8_hvt ad=0 pd=0 as=0 ps=0 w=200 l=30
X441 SUB SUB sky130_fd_sc_hd__xor2_1_1/a_35_297# SUB sky130_fd_pr__nfet_01v8 ad=0 pd=0 as=0 ps=0 w=130 l=30
X442 SUB sky130_fd_sc_hd__xor2_1_1/a_35_297# sky130_fd_sc_hd__xor2_1_1/X SUB sky130_fd_pr__nfet_01v8 ad=0 pd=0 as=0 ps=0 w=130 l=30
X443 sky130_fd_sc_hd__xor2_1_1/a_285_297# SUB SUB SUB sky130_fd_pr__pfet_01v8_hvt ad=0 pd=0 as=0 ps=0 w=200 l=30
X444 SUB SUB sky130_fd_sc_hd__xor2_1_1/a_117_297# SUB sky130_fd_pr__pfet_01v8_hvt ad=0 pd=0 as=0 ps=0 w=200 l=30
X445 sky130_fd_sc_hd__xor2_1_1/a_285_47# SUB SUB SUB sky130_fd_pr__nfet_01v8 ad=0 pd=0 as=0 ps=0 w=130 l=30
X446 sky130_fd_sc_hd__xor2_1_2/X sky130_fd_sc_hd__xor2_1_2/a_35_297# sky130_fd_sc_hd__xor2_1_2/a_285_297# SUB sky130_fd_pr__pfet_01v8_hvt ad=12n pd=0.52m as=21.2n ps=1.012m w=200 l=30
X447 sky130_fd_sc_hd__xor2_1_2/X sky130_fd_sc_hd__xor2_1_2/B sky130_fd_sc_hd__xor2_1_2/a_285_47# SUB sky130_fd_pr__nfet_01v8 ad=20.02n pd=0.568m as=7.02n ps=0.368m w=130 l=30
X448 sky130_fd_sc_hd__xor2_1_2/a_35_297# sky130_fd_sc_hd__xor2_1_2/B SUB SUB sky130_fd_pr__nfet_01v8 ad=7.02n pd=0.368m as=0 ps=0 w=130 l=30
X449 sky130_fd_sc_hd__xor2_1_2/a_117_297# sky130_fd_sc_hd__xor2_1_2/B sky130_fd_sc_hd__xor2_1_2/a_35_297# SUB sky130_fd_pr__pfet_01v8_hvt ad=10.8n pd=0.508m as=10.4n ps=0.504m w=200 l=30
X450 SUB sky130_fd_sc_hd__xor2_1_2/B sky130_fd_sc_hd__xor2_1_2/a_285_297# SUB sky130_fd_pr__pfet_01v8_hvt ad=0 pd=0 as=0 ps=0 w=200 l=30
X451 SUB SUB sky130_fd_sc_hd__xor2_1_2/a_35_297# SUB sky130_fd_pr__nfet_01v8 ad=0 pd=0 as=0 ps=0 w=130 l=30
X452 SUB sky130_fd_sc_hd__xor2_1_2/a_35_297# sky130_fd_sc_hd__xor2_1_2/X SUB sky130_fd_pr__nfet_01v8 ad=0 pd=0 as=0 ps=0 w=130 l=30
X453 sky130_fd_sc_hd__xor2_1_2/a_285_297# SUB SUB SUB sky130_fd_pr__pfet_01v8_hvt ad=0 pd=0 as=0 ps=0 w=200 l=30
X454 SUB SUB sky130_fd_sc_hd__xor2_1_2/a_117_297# SUB sky130_fd_pr__pfet_01v8_hvt ad=0 pd=0 as=0 ps=0 w=200 l=30
X455 sky130_fd_sc_hd__xor2_1_2/a_285_47# SUB SUB SUB sky130_fd_pr__nfet_01v8 ad=0 pd=0 as=0 ps=0 w=130 l=30
C0 sky130_fd_sc_hd__xnor2_1_2/A SUB 4.38019f
C1 sky130_fd_sc_hd__nor2_1_0/A SUB 2.95037f
C2 sky130_fd_sc_hd__clkbuf_2_2/X SUB 2.1966f
C3 sky130_fd_sc_hd__inv_2_0/Y SUB 9.5438f
C4 sky130_fd_sc_hd__buf_4_2/A SUB 2.43952f
C5 sky130_fd_sc_hd__ha_1_0/A SUB 3.95428f
C6 sky130_fd_sc_hd__buf_4_1/A SUB 2.83172f
C7 sky130_fd_sc_hd__ha_1_0/B SUB 3.73354f
C8 sky130_fd_sc_hd__clkbuf_2_1/X SUB 2.61761f
