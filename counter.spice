* SPICE3 file created from counter.ext - technology: sky130A

X0 sky130_fd_sc_hd__ha_1_0/a_674_47# sky130_fd_sc_hd__ha_1_0/B sky130_fd_sc_hd__ha_1_0/a_250_199# VSUBS sky130_fd_pr__nfet_01v8 ad=2.425e+09p pd=0u as=1.67772e+15p ps=0u w=420000u l=150000u
X1 sky130_fd_sc_hd__ha_1_0/a_297_47# sky130_fd_sc_hd__ha_1_0/a_250_199# sky130_fd_sc_hd__ha_1_0/a_79_21# VSUBS sky130_fd_pr__nfet_01v8 ad=0p pd=0u as=0p ps=0u w=420000u l=150000u
X2 VSUBS sky130_fd_sc_hd__ha_1_0/A sky130_fd_sc_hd__ha_1_0/a_250_199# VSUBS sky130_fd_pr__pfet_01v8_hvt ad=-2.30425e+11p pd=-5000u as=0p ps=0u w=420000u l=150000u
X3 sky130_fd_sc_hd__xor2_1_2/B sky130_fd_sc_hd__ha_1_0/a_250_199# VSUBS VSUBS sky130_fd_pr__pfet_01v8_hvt ad=2.425e+09p pd=0u as=-0p ps=-0u w=1e+06u l=150000u
X4 sky130_fd_sc_hd__ha_1_0/a_297_47# sky130_fd_sc_hd__ha_1_0/A VSUBS VSUBS sky130_fd_pr__nfet_01v8 ad=0p pd=0u as=-0p ps=-0u w=420000u l=150000u
X5 sky130_fd_sc_hd__ha_1_0/a_376_413# sky130_fd_sc_hd__ha_1_0/B sky130_fd_sc_hd__ha_1_0/a_79_21# VSUBS sky130_fd_pr__pfet_01v8_hvt ad=0p pd=0u as=0p ps=0u w=420000u l=150000u
X6 VSUBS sky130_fd_sc_hd__ha_1_0/A sky130_fd_sc_hd__ha_1_0/a_376_413# VSUBS sky130_fd_pr__pfet_01v8_hvt ad=-0p pd=-0u as=0p ps=0u w=420000u l=150000u
X7 VSUBS sky130_fd_sc_hd__ha_1_0/a_79_21# sky130_fd_sc_hd__ha_1_0/SUM VSUBS sky130_fd_pr__nfet_01v8 ad=-0p pd=-0u as=1.3575e+10p ps=0u w=650000u l=150000u
X8 VSUBS sky130_fd_sc_hd__ha_1_0/A sky130_fd_sc_hd__ha_1_0/a_674_47# VSUBS sky130_fd_pr__nfet_01v8 ad=-0p pd=-0u as=0p ps=0u w=420000u l=150000u
X9 VSUBS sky130_fd_sc_hd__ha_1_0/a_79_21# sky130_fd_sc_hd__ha_1_0/SUM VSUBS sky130_fd_pr__pfet_01v8_hvt ad=-0p pd=-0u as=0p ps=0u w=1e+06u l=150000u
X10 sky130_fd_sc_hd__ha_1_0/a_79_21# sky130_fd_sc_hd__ha_1_0/a_250_199# VSUBS VSUBS sky130_fd_pr__pfet_01v8_hvt ad=0p pd=0u as=-0p ps=-0u w=420000u l=150000u
X11 VSUBS sky130_fd_sc_hd__ha_1_0/B sky130_fd_sc_hd__ha_1_0/a_297_47# VSUBS sky130_fd_pr__nfet_01v8 ad=-0p pd=-0u as=0p ps=0u w=420000u l=150000u
X12 sky130_fd_sc_hd__xor2_1_2/B sky130_fd_sc_hd__ha_1_0/a_250_199# VSUBS VSUBS sky130_fd_pr__nfet_01v8 ad=0p pd=0u as=-0p ps=-0u w=650000u l=150000u
X13 sky130_fd_sc_hd__ha_1_0/a_250_199# sky130_fd_sc_hd__ha_1_0/B VSUBS VSUBS sky130_fd_pr__pfet_01v8_hvt ad=0p pd=0u as=-0p ps=-0u w=420000u l=150000u
X14 VSUBS sky130_fd_sc_hd__dfrtp_1_0/a_1283_21# sky130_fd_sc_hd__dfrtp_1_0/a_1270_413# VSUBS sky130_fd_pr__pfet_01v8_hvt ad=-0p pd=-0u as=2e+08p ps=0u w=420000u l=150000u
X15 sky130_fd_sc_hd__dfrtp_1_0/a_761_289# sky130_fd_sc_hd__dfrtp_1_0/a_543_47# VSUBS VSUBS sky130_fd_pr__pfet_01v8_hvt ad=0p pd=0u as=-0p ps=-0u w=840000u l=150000u
X16 sky130_fd_sc_hd__dfrtp_1_0/a_761_289# sky130_fd_sc_hd__dfrtp_1_0/a_543_47# VSUBS VSUBS sky130_fd_pr__nfet_01v8 ad=0p pd=0u as=-0p ps=-0u w=640000u l=150000u
X17 sky130_fd_sc_hd__dfrtp_1_0/a_448_47# sky130_fd_sc_hd__xor2_1_0/X VSUBS VSUBS sky130_fd_pr__nfet_01v8 ad=0p pd=0u as=-0p ps=-0u w=420000u l=150000u
X18 sky130_fd_sc_hd__dfrtp_1_0/a_1270_413# sky130_fd_sc_hd__dfrtp_1_0/a_193_47# sky130_fd_sc_hd__dfrtp_1_0/a_1108_47# VSUBS sky130_fd_pr__pfet_01v8_hvt ad=0p pd=0u as=2.55072e+13p ps=0u w=420000u l=150000u
X19 sky130_fd_sc_hd__buf_4_0/A sky130_fd_sc_hd__dfrtp_1_0/a_1283_21# VSUBS VSUBS sky130_fd_pr__nfet_01v8 ad=1.67772e+15p pd=0u as=-0p ps=-0u w=650000u l=150000u
X20 VSUBS sky130_fd_sc_hd__dfrtp_1_0/a_1283_21# sky130_fd_sc_hd__dfrtp_1_0/a_1217_47# VSUBS sky130_fd_pr__nfet_01v8 ad=-0p pd=-0u as=6.75e+08p ps=0u w=420000u l=150000u
X21 sky130_fd_sc_hd__dfrtp_1_0/a_543_47# sky130_fd_sc_hd__dfrtp_1_0/a_27_47# sky130_fd_sc_hd__dfrtp_1_0/a_448_47# VSUBS sky130_fd_pr__nfet_01v8 ad=0p pd=0u as=0p ps=0u w=360000u l=150000u
X22 sky130_fd_sc_hd__dfrtp_1_0/a_543_47# sky130_fd_sc_hd__dfrtp_1_0/a_193_47# sky130_fd_sc_hd__dfrtp_1_0/a_448_47# VSUBS sky130_fd_pr__pfet_01v8_hvt ad=0p pd=0u as=0p ps=0u w=420000u l=150000u
X23 sky130_fd_sc_hd__dfrtp_1_0/a_639_47# sky130_fd_sc_hd__dfrtp_1_0/a_193_47# sky130_fd_sc_hd__dfrtp_1_0/a_543_47# VSUBS sky130_fd_pr__nfet_01v8 ad=5.27613e+16p pd=1.27315e+08u as=0p ps=0u w=360000u l=150000u
X24 sky130_fd_sc_hd__dfrtp_1_0/a_1217_47# sky130_fd_sc_hd__dfrtp_1_0/a_27_47# sky130_fd_sc_hd__dfrtp_1_0/a_1108_47# VSUBS sky130_fd_pr__nfet_01v8 ad=0p pd=0u as=0p ps=0u w=360000u l=150000u
X25 sky130_fd_sc_hd__dfrtp_1_0/a_1283_21# sky130_fd_sc_hd__dfrtp_1_0/a_1108_47# sky130_fd_sc_hd__dfrtp_1_0/a_1462_47# VSUBS sky130_fd_pr__nfet_01v8 ad=0p pd=0u as=0p ps=0u w=420000u l=150000u
X26 sky130_fd_sc_hd__dfrtp_1_0/a_651_413# sky130_fd_sc_hd__dfrtp_1_0/a_27_47# sky130_fd_sc_hd__dfrtp_1_0/a_543_47# VSUBS sky130_fd_pr__pfet_01v8_hvt ad=0p pd=0u as=0p ps=0u w=420000u l=150000u
X27 VSUBS sky130_fd_sc_hd__inv_2_0/Y sky130_fd_sc_hd__dfrtp_1_0/a_805_47# VSUBS sky130_fd_pr__nfet_01v8 ad=-0p pd=-0u as=1.65221e+15p ps=0u w=420000u l=150000u
X28 sky130_fd_sc_hd__dfrtp_1_0/a_1108_47# sky130_fd_sc_hd__dfrtp_1_0/a_193_47# sky130_fd_sc_hd__dfrtp_1_0/a_761_289# VSUBS sky130_fd_pr__nfet_01v8 ad=0p pd=0u as=0p ps=0u w=360000u l=150000u
X29 sky130_fd_sc_hd__dfrtp_1_0/a_651_413# sky130_fd_sc_hd__inv_2_0/Y VSUBS VSUBS sky130_fd_pr__pfet_01v8_hvt ad=0p pd=0u as=-0p ps=-0u w=420000u l=150000u
X30 sky130_fd_sc_hd__dfrtp_1_0/a_193_47# sky130_fd_sc_hd__dfrtp_1_0/a_27_47# VSUBS VSUBS sky130_fd_pr__nfet_01v8 ad=0p pd=0u as=-0p ps=-0u w=420000u l=150000u
X31 VSUBS sky130_fd_sc_hd__clkbuf_2_1/X sky130_fd_sc_hd__dfrtp_1_0/a_27_47# VSUBS sky130_fd_pr__nfet_01v8 ad=-0p pd=-0u as=0p ps=0u w=420000u l=150000u
X32 VSUBS sky130_fd_sc_hd__clkbuf_2_1/X sky130_fd_sc_hd__dfrtp_1_0/a_27_47# VSUBS sky130_fd_pr__pfet_01v8_hvt ad=-0p pd=-0u as=0p ps=0u w=640000u l=150000u
X33 sky130_fd_sc_hd__buf_4_0/A sky130_fd_sc_hd__dfrtp_1_0/a_1283_21# VSUBS VSUBS sky130_fd_pr__pfet_01v8_hvt ad=0p pd=0u as=-0p ps=-0u w=1e+06u l=150000u
X34 sky130_fd_sc_hd__dfrtp_1_0/a_193_47# sky130_fd_sc_hd__dfrtp_1_0/a_27_47# VSUBS VSUBS sky130_fd_pr__pfet_01v8_hvt ad=0p pd=0u as=-0p ps=-0u w=640000u l=150000u
X35 VSUBS sky130_fd_sc_hd__dfrtp_1_0/a_1108_47# sky130_fd_sc_hd__dfrtp_1_0/a_1283_21# VSUBS sky130_fd_pr__pfet_01v8_hvt ad=-0p pd=-0u as=0p ps=0u w=420000u l=150000u
X36 sky130_fd_sc_hd__dfrtp_1_0/a_1462_47# sky130_fd_sc_hd__inv_2_0/Y VSUBS VSUBS sky130_fd_pr__nfet_01v8 ad=0p pd=0u as=-0p ps=-0u w=420000u l=150000u
X37 sky130_fd_sc_hd__dfrtp_1_0/a_448_47# sky130_fd_sc_hd__xor2_1_0/X VSUBS VSUBS sky130_fd_pr__pfet_01v8_hvt ad=0p pd=0u as=-0p ps=-0u w=420000u l=150000u
X38 VSUBS sky130_fd_sc_hd__dfrtp_1_0/a_761_289# sky130_fd_sc_hd__dfrtp_1_0/a_651_413# VSUBS sky130_fd_pr__pfet_01v8_hvt ad=-0p pd=-0u as=0p ps=0u w=420000u l=150000u
X39 sky130_fd_sc_hd__dfrtp_1_0/a_1108_47# sky130_fd_sc_hd__dfrtp_1_0/a_27_47# sky130_fd_sc_hd__dfrtp_1_0/a_761_289# VSUBS sky130_fd_pr__pfet_01v8_hvt ad=0p pd=0u as=0p ps=0u w=420000u l=150000u
X40 sky130_fd_sc_hd__dfrtp_1_0/a_1283_21# sky130_fd_sc_hd__inv_2_0/Y VSUBS VSUBS sky130_fd_pr__pfet_01v8_hvt ad=0p pd=0u as=-0p ps=-0u w=420000u l=150000u
X41 sky130_fd_sc_hd__dfrtp_1_0/a_805_47# sky130_fd_sc_hd__dfrtp_1_0/a_761_289# sky130_fd_sc_hd__dfrtp_1_0/a_639_47# VSUBS sky130_fd_pr__nfet_01v8 ad=0p pd=0u as=0p ps=0u w=420000u l=150000u
X42 VSUBS sky130_fd_sc_hd__dfrtp_1_1/a_1283_21# sky130_fd_sc_hd__dfrtp_1_1/a_1270_413# VSUBS sky130_fd_pr__pfet_01v8_hvt ad=-0p pd=-0u as=5.2383e+16p ps=1.27315e+08u w=420000u l=150000u
X43 sky130_fd_sc_hd__dfrtp_1_1/a_761_289# sky130_fd_sc_hd__dfrtp_1_1/a_543_47# VSUBS VSUBS sky130_fd_pr__pfet_01v8_hvt ad=1.67772e+15p pd=0u as=-0p ps=-0u w=840000u l=150000u
X44 sky130_fd_sc_hd__dfrtp_1_1/a_761_289# sky130_fd_sc_hd__dfrtp_1_1/a_543_47# VSUBS VSUBS sky130_fd_pr__nfet_01v8 ad=0p pd=0u as=-0p ps=-0u w=640000u l=150000u
X45 sky130_fd_sc_hd__dfrtp_1_1/a_448_47# sky130_fd_sc_hd__xnor2_1_2/Y VSUBS VSUBS sky130_fd_pr__nfet_01v8 ad=2.825e+09p pd=0u as=-0p ps=-0u w=420000u l=150000u
X46 sky130_fd_sc_hd__dfrtp_1_1/a_1270_413# sky130_fd_sc_hd__dfrtp_1_1/a_193_47# sky130_fd_sc_hd__dfrtp_1_1/a_1108_47# VSUBS sky130_fd_pr__pfet_01v8_hvt ad=0p pd=0u as=1.225e+09p ps=0u w=420000u l=150000u
X47 sky130_fd_sc_hd__xnor2_1_2/A sky130_fd_sc_hd__dfrtp_1_1/a_1283_21# VSUBS VSUBS sky130_fd_pr__nfet_01v8 ad=0p pd=0u as=-0p ps=-0u w=650000u l=150000u
X48 VSUBS sky130_fd_sc_hd__dfrtp_1_1/a_1283_21# sky130_fd_sc_hd__dfrtp_1_1/a_1217_47# VSUBS sky130_fd_pr__nfet_01v8 ad=-0p pd=-0u as=1.34218e+16p ps=0u w=420000u l=150000u
X49 sky130_fd_sc_hd__dfrtp_1_1/a_543_47# sky130_fd_sc_hd__dfrtp_1_1/a_27_47# sky130_fd_sc_hd__dfrtp_1_1/a_448_47# VSUBS sky130_fd_pr__nfet_01v8 ad=0p pd=0u as=0p ps=0u w=360000u l=150000u
X50 sky130_fd_sc_hd__dfrtp_1_1/a_543_47# sky130_fd_sc_hd__dfrtp_1_1/a_193_47# sky130_fd_sc_hd__dfrtp_1_1/a_448_47# VSUBS sky130_fd_pr__pfet_01v8_hvt ad=0p pd=0u as=0p ps=0u w=420000u l=150000u
X51 sky130_fd_sc_hd__dfrtp_1_1/a_639_47# sky130_fd_sc_hd__dfrtp_1_1/a_193_47# sky130_fd_sc_hd__dfrtp_1_1/a_543_47# VSUBS sky130_fd_pr__nfet_01v8 ad=1.34218e+16p pd=0u as=0p ps=0u w=360000u l=150000u
X52 sky130_fd_sc_hd__dfrtp_1_1/a_1217_47# sky130_fd_sc_hd__dfrtp_1_1/a_27_47# sky130_fd_sc_hd__dfrtp_1_1/a_1108_47# VSUBS sky130_fd_pr__nfet_01v8 ad=0p pd=0u as=0p ps=0u w=360000u l=150000u
X53 sky130_fd_sc_hd__dfrtp_1_1/a_1283_21# sky130_fd_sc_hd__dfrtp_1_1/a_1108_47# sky130_fd_sc_hd__dfrtp_1_1/a_1462_47# VSUBS sky130_fd_pr__nfet_01v8 ad=1.67772e+15p pd=0u as=-1.36e+10p ps=-5000u w=420000u l=150000u
X54 sky130_fd_sc_hd__dfrtp_1_1/a_651_413# sky130_fd_sc_hd__dfrtp_1_1/a_27_47# sky130_fd_sc_hd__dfrtp_1_1/a_543_47# VSUBS sky130_fd_pr__pfet_01v8_hvt ad=0p pd=0u as=0p ps=0u w=420000u l=150000u
X55 VSUBS sky130_fd_sc_hd__inv_2_0/Y sky130_fd_sc_hd__dfrtp_1_1/a_805_47# VSUBS sky130_fd_pr__nfet_01v8 ad=-0p pd=-0u as=4.025e+09p ps=0u w=420000u l=150000u
X56 sky130_fd_sc_hd__dfrtp_1_1/a_1108_47# sky130_fd_sc_hd__dfrtp_1_1/a_193_47# sky130_fd_sc_hd__dfrtp_1_1/a_761_289# VSUBS sky130_fd_pr__nfet_01v8 ad=0p pd=0u as=0p ps=0u w=360000u l=150000u
X57 sky130_fd_sc_hd__dfrtp_1_1/a_651_413# sky130_fd_sc_hd__inv_2_0/Y VSUBS VSUBS sky130_fd_pr__pfet_01v8_hvt ad=0p pd=0u as=-0p ps=-0u w=420000u l=150000u
X58 sky130_fd_sc_hd__dfrtp_1_1/a_193_47# sky130_fd_sc_hd__dfrtp_1_1/a_27_47# VSUBS VSUBS sky130_fd_pr__nfet_01v8 ad=1.67772e+15p pd=0u as=-0p ps=-0u w=420000u l=150000u
X59 VSUBS VSUBS sky130_fd_sc_hd__dfrtp_1_1/a_27_47# VSUBS sky130_fd_pr__nfet_01v8 ad=-0p pd=-0u as=0p ps=0u w=420000u l=150000u
X60 VSUBS VSUBS sky130_fd_sc_hd__dfrtp_1_1/a_27_47# VSUBS sky130_fd_pr__pfet_01v8_hvt ad=-0p pd=-0u as=0p ps=0u w=640000u l=150000u
X61 sky130_fd_sc_hd__xnor2_1_2/A sky130_fd_sc_hd__dfrtp_1_1/a_1283_21# VSUBS VSUBS sky130_fd_pr__pfet_01v8_hvt ad=0p pd=0u as=-0p ps=-0u w=1e+06u l=150000u
X62 sky130_fd_sc_hd__dfrtp_1_1/a_193_47# sky130_fd_sc_hd__dfrtp_1_1/a_27_47# VSUBS VSUBS sky130_fd_pr__pfet_01v8_hvt ad=0p pd=0u as=-0p ps=-0u w=640000u l=150000u
X63 VSUBS sky130_fd_sc_hd__dfrtp_1_1/a_1108_47# sky130_fd_sc_hd__dfrtp_1_1/a_1283_21# VSUBS sky130_fd_pr__pfet_01v8_hvt ad=-0p pd=-0u as=0p ps=0u w=420000u l=150000u
X64 sky130_fd_sc_hd__dfrtp_1_1/a_1462_47# sky130_fd_sc_hd__inv_2_0/Y VSUBS VSUBS sky130_fd_pr__nfet_01v8 ad=-0p pd=-0u as=-0p ps=-0u w=420000u l=150000u
X65 sky130_fd_sc_hd__dfrtp_1_1/a_448_47# sky130_fd_sc_hd__xnor2_1_2/Y VSUBS VSUBS sky130_fd_pr__pfet_01v8_hvt ad=0p pd=0u as=-0p ps=-0u w=420000u l=150000u
X66 VSUBS sky130_fd_sc_hd__dfrtp_1_1/a_761_289# sky130_fd_sc_hd__dfrtp_1_1/a_651_413# VSUBS sky130_fd_pr__pfet_01v8_hvt ad=-0p pd=-0u as=0p ps=0u w=420000u l=150000u
X67 sky130_fd_sc_hd__dfrtp_1_1/a_1108_47# sky130_fd_sc_hd__dfrtp_1_1/a_27_47# sky130_fd_sc_hd__dfrtp_1_1/a_761_289# VSUBS sky130_fd_pr__pfet_01v8_hvt ad=0p pd=0u as=0p ps=0u w=420000u l=150000u
X68 sky130_fd_sc_hd__dfrtp_1_1/a_1283_21# sky130_fd_sc_hd__inv_2_0/Y VSUBS VSUBS sky130_fd_pr__pfet_01v8_hvt ad=0p pd=0u as=-0p ps=-0u w=420000u l=150000u
X69 sky130_fd_sc_hd__dfrtp_1_1/a_805_47# sky130_fd_sc_hd__dfrtp_1_1/a_761_289# sky130_fd_sc_hd__dfrtp_1_1/a_639_47# VSUBS sky130_fd_pr__nfet_01v8 ad=0p pd=0u as=0p ps=0u w=420000u l=150000u
X70 VSUBS sky130_fd_sc_hd__nor2_1_0/A sky130_fd_sc_hd__nor2_1_0/a_109_297# VSUBS sky130_fd_pr__pfet_01v8_hvt ad=-0p pd=-0u as=1.3575e+10p ps=0u w=1e+06u l=150000u
X71 VSUBS sky130_fd_sc_hd__nor2_1_0/A sky130_fd_sc_hd__xor2_1_1/B VSUBS sky130_fd_pr__nfet_01v8 ad=-0p pd=-0u as=0p ps=0u w=650000u l=150000u
X72 sky130_fd_sc_hd__xor2_1_1/B sky130_fd_sc_hd__nor3_1_0/B VSUBS VSUBS sky130_fd_pr__nfet_01v8 ad=0p pd=0u as=-0p ps=-0u w=650000u l=150000u
X73 sky130_fd_sc_hd__nor2_1_0/a_109_297# sky130_fd_sc_hd__nor3_1_0/B sky130_fd_sc_hd__xor2_1_1/B VSUBS sky130_fd_pr__pfet_01v8_hvt ad=0p pd=0u as=0p ps=0u w=1e+06u l=150000u
X74 VSUBS sky130_fd_sc_hd__dfrtp_1_2/a_1283_21# sky130_fd_sc_hd__dfrtp_1_2/a_1270_413# VSUBS sky130_fd_pr__pfet_01v8_hvt ad=-0p pd=-0u as=1.65995e+15p ps=0u w=420000u l=150000u
X75 sky130_fd_sc_hd__dfrtp_1_2/a_761_289# sky130_fd_sc_hd__dfrtp_1_2/a_543_47# VSUBS VSUBS sky130_fd_pr__pfet_01v8_hvt ad=0p pd=0u as=-0p ps=-0u w=840000u l=150000u
X76 sky130_fd_sc_hd__dfrtp_1_2/a_761_289# sky130_fd_sc_hd__dfrtp_1_2/a_543_47# VSUBS VSUBS sky130_fd_pr__nfet_01v8 ad=0p pd=0u as=-0p ps=-0u w=640000u l=150000u
X77 sky130_fd_sc_hd__dfrtp_1_2/a_448_47# sky130_fd_sc_hd__inv_1_0/Y VSUBS VSUBS sky130_fd_pr__nfet_01v8 ad=0p pd=0u as=-0p ps=-0u w=420000u l=150000u
X78 sky130_fd_sc_hd__dfrtp_1_2/a_1270_413# sky130_fd_sc_hd__dfrtp_1_2/a_193_47# sky130_fd_sc_hd__dfrtp_1_2/a_1108_47# VSUBS sky130_fd_pr__pfet_01v8_hvt ad=0p pd=0u as=1.225e+09p ps=0u w=420000u l=150000u
X79 sky130_fd_sc_hd__ha_1_0/A sky130_fd_sc_hd__dfrtp_1_2/a_1283_21# VSUBS VSUBS sky130_fd_pr__nfet_01v8 ad=0p pd=0u as=-0p ps=-0u w=650000u l=150000u
X80 VSUBS sky130_fd_sc_hd__dfrtp_1_2/a_1283_21# sky130_fd_sc_hd__dfrtp_1_2/a_1217_47# VSUBS sky130_fd_pr__nfet_01v8 ad=-0p pd=-0u as=6.75e+08p ps=0u w=420000u l=150000u
X81 sky130_fd_sc_hd__dfrtp_1_2/a_543_47# sky130_fd_sc_hd__dfrtp_1_2/a_27_47# sky130_fd_sc_hd__dfrtp_1_2/a_448_47# VSUBS sky130_fd_pr__nfet_01v8 ad=4.17126e+16p pd=8.00208e+12u as=0p ps=0u w=360000u l=150000u
X82 sky130_fd_sc_hd__dfrtp_1_2/a_543_47# sky130_fd_sc_hd__dfrtp_1_2/a_193_47# sky130_fd_sc_hd__dfrtp_1_2/a_448_47# VSUBS sky130_fd_pr__pfet_01v8_hvt ad=0p pd=0u as=0p ps=0u w=420000u l=150000u
X83 sky130_fd_sc_hd__dfrtp_1_2/a_639_47# sky130_fd_sc_hd__dfrtp_1_2/a_193_47# sky130_fd_sc_hd__dfrtp_1_2/a_543_47# VSUBS sky130_fd_pr__nfet_01v8 ad=0p pd=0u as=0p ps=0u w=360000u l=150000u
X84 sky130_fd_sc_hd__dfrtp_1_2/a_1217_47# sky130_fd_sc_hd__dfrtp_1_2/a_27_47# sky130_fd_sc_hd__dfrtp_1_2/a_1108_47# VSUBS sky130_fd_pr__nfet_01v8 ad=0p pd=0u as=0p ps=0u w=360000u l=150000u
X85 sky130_fd_sc_hd__dfrtp_1_2/a_1283_21# sky130_fd_sc_hd__dfrtp_1_2/a_1108_47# sky130_fd_sc_hd__dfrtp_1_2/a_1462_47# VSUBS sky130_fd_pr__nfet_01v8 ad=0p pd=0u as=1.67772e+15p ps=0u w=420000u l=150000u
X86 sky130_fd_sc_hd__dfrtp_1_2/a_651_413# sky130_fd_sc_hd__dfrtp_1_2/a_27_47# sky130_fd_sc_hd__dfrtp_1_2/a_543_47# VSUBS sky130_fd_pr__pfet_01v8_hvt ad=1.225e+09p pd=0u as=0p ps=0u w=420000u l=150000u
X87 VSUBS sky130_fd_sc_hd__inv_2_0/Y sky130_fd_sc_hd__dfrtp_1_2/a_805_47# VSUBS sky130_fd_pr__nfet_01v8 ad=-0p pd=-0u as=0p ps=0u w=420000u l=150000u
X88 sky130_fd_sc_hd__dfrtp_1_2/a_1108_47# sky130_fd_sc_hd__dfrtp_1_2/a_193_47# sky130_fd_sc_hd__dfrtp_1_2/a_761_289# VSUBS sky130_fd_pr__nfet_01v8 ad=0p pd=0u as=0p ps=0u w=360000u l=150000u
X89 sky130_fd_sc_hd__dfrtp_1_2/a_651_413# sky130_fd_sc_hd__inv_2_0/Y VSUBS VSUBS sky130_fd_pr__pfet_01v8_hvt ad=0p pd=0u as=-0p ps=-0u w=420000u l=150000u
X90 sky130_fd_sc_hd__dfrtp_1_2/a_193_47# sky130_fd_sc_hd__dfrtp_1_2/a_27_47# VSUBS VSUBS sky130_fd_pr__nfet_01v8 ad=3.99808e+16p pd=8.00195e+12u as=-0p ps=-0u w=420000u l=150000u
X91 VSUBS VSUBS sky130_fd_sc_hd__dfrtp_1_2/a_27_47# VSUBS sky130_fd_pr__nfet_01v8 ad=-0p pd=-0u as=0p ps=0u w=420000u l=150000u
X92 VSUBS VSUBS sky130_fd_sc_hd__dfrtp_1_2/a_27_47# VSUBS sky130_fd_pr__pfet_01v8_hvt ad=-0p pd=-0u as=0p ps=0u w=640000u l=150000u
X93 sky130_fd_sc_hd__ha_1_0/A sky130_fd_sc_hd__dfrtp_1_2/a_1283_21# VSUBS VSUBS sky130_fd_pr__pfet_01v8_hvt ad=0p pd=0u as=-0p ps=-0u w=1e+06u l=150000u
X94 sky130_fd_sc_hd__dfrtp_1_2/a_193_47# sky130_fd_sc_hd__dfrtp_1_2/a_27_47# VSUBS VSUBS sky130_fd_pr__pfet_01v8_hvt ad=0p pd=0u as=-0p ps=-0u w=640000u l=150000u
X95 VSUBS sky130_fd_sc_hd__dfrtp_1_2/a_1108_47# sky130_fd_sc_hd__dfrtp_1_2/a_1283_21# VSUBS sky130_fd_pr__pfet_01v8_hvt ad=-0p pd=-0u as=0p ps=0u w=420000u l=150000u
X96 sky130_fd_sc_hd__dfrtp_1_2/a_1462_47# sky130_fd_sc_hd__inv_2_0/Y VSUBS VSUBS sky130_fd_pr__nfet_01v8 ad=0p pd=0u as=-0p ps=-0u w=420000u l=150000u
X97 sky130_fd_sc_hd__dfrtp_1_2/a_448_47# sky130_fd_sc_hd__inv_1_0/Y VSUBS VSUBS sky130_fd_pr__pfet_01v8_hvt ad=0p pd=0u as=-0p ps=-0u w=420000u l=150000u
X98 VSUBS sky130_fd_sc_hd__dfrtp_1_2/a_761_289# sky130_fd_sc_hd__dfrtp_1_2/a_651_413# VSUBS sky130_fd_pr__pfet_01v8_hvt ad=-0p pd=-0u as=0p ps=0u w=420000u l=150000u
X99 sky130_fd_sc_hd__dfrtp_1_2/a_1108_47# sky130_fd_sc_hd__dfrtp_1_2/a_27_47# sky130_fd_sc_hd__dfrtp_1_2/a_761_289# VSUBS sky130_fd_pr__pfet_01v8_hvt ad=0p pd=0u as=0p ps=0u w=420000u l=150000u
X100 sky130_fd_sc_hd__dfrtp_1_2/a_1283_21# sky130_fd_sc_hd__inv_2_0/Y VSUBS VSUBS sky130_fd_pr__pfet_01v8_hvt ad=0p pd=0u as=-0p ps=-0u w=420000u l=150000u
X101 sky130_fd_sc_hd__dfrtp_1_2/a_805_47# sky130_fd_sc_hd__dfrtp_1_2/a_761_289# sky130_fd_sc_hd__dfrtp_1_2/a_639_47# VSUBS sky130_fd_pr__nfet_01v8 ad=0p pd=0u as=0p ps=0u w=420000u l=150000u
X102 sky130_fd_sc_hd__xnor2_1_0/a_377_297# sky130_fd_sc_hd__buf_4_1/A VSUBS VSUBS sky130_fd_pr__pfet_01v8_hvt ad=1.67771e+15p pd=0u as=-0p ps=-0u w=1e+06u l=150000u
X103 sky130_fd_sc_hd__xnor2_1_0/Y sky130_fd_sc_hd__nor2_1_0/A sky130_fd_sc_hd__xnor2_1_0/a_377_297# VSUBS sky130_fd_pr__pfet_01v8_hvt ad=0p pd=0u as=0p ps=0u w=1e+06u l=150000u
X104 VSUBS sky130_fd_sc_hd__xnor2_1_0/a_47_47# sky130_fd_sc_hd__xnor2_1_0/Y VSUBS sky130_fd_pr__pfet_01v8_hvt ad=-0p pd=-0u as=0p ps=0u w=1e+06u l=150000u
X105 VSUBS sky130_fd_sc_hd__buf_4_1/A sky130_fd_sc_hd__xnor2_1_0/a_129_47# VSUBS sky130_fd_pr__nfet_01v8 ad=-0p pd=-0u as=1.66953e+15p ps=0u w=650000u l=150000u
X106 sky130_fd_sc_hd__xnor2_1_0/a_285_47# sky130_fd_sc_hd__nor2_1_0/A VSUBS VSUBS sky130_fd_pr__nfet_01v8 ad=0p pd=0u as=-0p ps=-0u w=650000u l=150000u
X107 sky130_fd_sc_hd__xnor2_1_0/a_129_47# sky130_fd_sc_hd__nor2_1_0/A sky130_fd_sc_hd__xnor2_1_0/a_47_47# VSUBS sky130_fd_pr__nfet_01v8 ad=0p pd=0u as=-1.36e+10p ps=-5000u w=650000u l=150000u
X108 sky130_fd_sc_hd__xnor2_1_0/a_47_47# sky130_fd_sc_hd__nor2_1_0/A VSUBS VSUBS sky130_fd_pr__pfet_01v8_hvt ad=-0p pd=-0u as=-0p ps=-0u w=1e+06u l=150000u
X109 VSUBS sky130_fd_sc_hd__buf_4_1/A sky130_fd_sc_hd__xnor2_1_0/a_47_47# VSUBS sky130_fd_pr__pfet_01v8_hvt ad=-0p pd=-0u as=-0p ps=-0u w=1e+06u l=150000u
X110 sky130_fd_sc_hd__xnor2_1_0/a_285_47# sky130_fd_sc_hd__buf_4_1/A VSUBS VSUBS sky130_fd_pr__nfet_01v8 ad=0p pd=0u as=-0p ps=-0u w=650000u l=150000u
X111 sky130_fd_sc_hd__xnor2_1_0/Y sky130_fd_sc_hd__xnor2_1_0/a_47_47# sky130_fd_sc_hd__xnor2_1_0/a_285_47# VSUBS sky130_fd_pr__nfet_01v8 ad=0p pd=0u as=0p ps=0u w=650000u l=150000u
X112 count[3] sky130_fd_sc_hd__clkbuf_4_0/a_27_47# VSUBS VSUBS sky130_fd_pr__pfet_01v8_hvt ad=0p pd=0u as=-0p ps=-0u w=1e+06u l=150000u
X113 VSUBS sky130_fd_sc_hd__clkbuf_4_0/a_27_47# count[3] VSUBS sky130_fd_pr__pfet_01v8_hvt ad=-0p pd=-0u as=0p ps=0u w=1e+06u l=150000u
X114 VSUBS sky130_fd_sc_hd__xnor2_1_2/A sky130_fd_sc_hd__clkbuf_4_0/a_27_47# VSUBS sky130_fd_pr__pfet_01v8_hvt ad=-0p pd=-0u as=0p ps=0u w=1e+06u l=150000u
X115 VSUBS sky130_fd_sc_hd__xnor2_1_2/A sky130_fd_sc_hd__clkbuf_4_0/a_27_47# VSUBS sky130_fd_pr__nfet_01v8 ad=-0p pd=-0u as=0p ps=0u w=420000u l=150000u
X116 VSUBS sky130_fd_sc_hd__clkbuf_4_0/a_27_47# count[3] VSUBS sky130_fd_pr__pfet_01v8_hvt ad=-0p pd=-0u as=0p ps=0u w=1e+06u l=150000u
X117 count[3] sky130_fd_sc_hd__clkbuf_4_0/a_27_47# VSUBS VSUBS sky130_fd_pr__nfet_01v8 ad=0p pd=0u as=-0p ps=-0u w=420000u l=150000u
X118 VSUBS sky130_fd_sc_hd__clkbuf_4_0/a_27_47# count[3] VSUBS sky130_fd_pr__nfet_01v8 ad=-0p pd=-0u as=0p ps=0u w=420000u l=150000u
X119 count[3] sky130_fd_sc_hd__clkbuf_4_0/a_27_47# VSUBS VSUBS sky130_fd_pr__nfet_01v8 ad=0p pd=0u as=-0p ps=-0u w=420000u l=150000u
X120 VSUBS sky130_fd_sc_hd__clkbuf_4_0/a_27_47# count[3] VSUBS sky130_fd_pr__nfet_01v8 ad=-0p pd=-0u as=0p ps=0u w=420000u l=150000u
X121 count[3] sky130_fd_sc_hd__clkbuf_4_0/a_27_47# VSUBS VSUBS sky130_fd_pr__pfet_01v8_hvt ad=0p pd=0u as=-0p ps=-0u w=1e+06u l=150000u
X122 VSUBS sky130_fd_sc_hd__dfrtp_1_3/a_1283_21# sky130_fd_sc_hd__dfrtp_1_3/a_1270_413# VSUBS sky130_fd_pr__pfet_01v8_hvt ad=-0p pd=-0u as=1.34218e+16p ps=0u w=420000u l=150000u
X123 sky130_fd_sc_hd__dfrtp_1_3/a_761_289# sky130_fd_sc_hd__dfrtp_1_3/a_543_47# VSUBS VSUBS sky130_fd_pr__pfet_01v8_hvt ad=5.30493e+16p pd=1.27315e+08u as=-0p ps=-0u w=840000u l=150000u
X124 sky130_fd_sc_hd__dfrtp_1_3/a_761_289# sky130_fd_sc_hd__dfrtp_1_3/a_543_47# VSUBS VSUBS sky130_fd_pr__nfet_01v8 ad=0p pd=0u as=-0p ps=-0u w=640000u l=150000u
X125 sky130_fd_sc_hd__dfrtp_1_3/a_448_47# sky130_fd_sc_hd__ha_1_0/SUM VSUBS VSUBS sky130_fd_pr__nfet_01v8 ad=0p pd=0u as=-0p ps=-0u w=420000u l=150000u
X126 sky130_fd_sc_hd__dfrtp_1_3/a_1270_413# sky130_fd_sc_hd__dfrtp_1_3/a_193_47# sky130_fd_sc_hd__dfrtp_1_3/a_1108_47# VSUBS sky130_fd_pr__pfet_01v8_hvt ad=0p pd=0u as=1.34218e+16p ps=0u w=420000u l=150000u
X127 sky130_fd_sc_hd__ha_1_0/B sky130_fd_sc_hd__dfrtp_1_3/a_1283_21# VSUBS VSUBS sky130_fd_pr__nfet_01v8 ad=5.31899e+16p pd=1.27315e+08u as=-0p ps=-0u w=650000u l=150000u
X128 VSUBS sky130_fd_sc_hd__dfrtp_1_3/a_1283_21# sky130_fd_sc_hd__dfrtp_1_3/a_1217_47# VSUBS sky130_fd_pr__nfet_01v8 ad=-0p pd=-0u as=1.34218e+16p ps=0u w=420000u l=150000u
X129 sky130_fd_sc_hd__dfrtp_1_3/a_543_47# sky130_fd_sc_hd__dfrtp_1_3/a_27_47# sky130_fd_sc_hd__dfrtp_1_3/a_448_47# VSUBS sky130_fd_pr__nfet_01v8 ad=1.6384e+13p pd=0u as=0p ps=0u w=360000u l=150000u
X130 sky130_fd_sc_hd__dfrtp_1_3/a_543_47# sky130_fd_sc_hd__dfrtp_1_3/a_193_47# sky130_fd_sc_hd__dfrtp_1_3/a_448_47# VSUBS sky130_fd_pr__pfet_01v8_hvt ad=0p pd=0u as=0p ps=0u w=420000u l=150000u
X131 sky130_fd_sc_hd__dfrtp_1_3/a_639_47# sky130_fd_sc_hd__dfrtp_1_3/a_193_47# sky130_fd_sc_hd__dfrtp_1_3/a_543_47# VSUBS sky130_fd_pr__nfet_01v8 ad=0p pd=0u as=0p ps=0u w=360000u l=150000u
X132 sky130_fd_sc_hd__dfrtp_1_3/a_1217_47# sky130_fd_sc_hd__dfrtp_1_3/a_27_47# sky130_fd_sc_hd__dfrtp_1_3/a_1108_47# VSUBS sky130_fd_pr__nfet_01v8 ad=0p pd=0u as=0p ps=0u w=360000u l=150000u
X133 sky130_fd_sc_hd__dfrtp_1_3/a_1283_21# sky130_fd_sc_hd__dfrtp_1_3/a_1108_47# sky130_fd_sc_hd__dfrtp_1_3/a_1462_47# VSUBS sky130_fd_pr__nfet_01v8 ad=2e+08p pd=475000u as=1.6384e+13p ps=0u w=420000u l=150000u
X134 sky130_fd_sc_hd__dfrtp_1_3/a_651_413# sky130_fd_sc_hd__dfrtp_1_3/a_27_47# sky130_fd_sc_hd__dfrtp_1_3/a_543_47# VSUBS sky130_fd_pr__pfet_01v8_hvt ad=2e+08p pd=475000u as=0p ps=0u w=420000u l=150000u
X135 VSUBS sky130_fd_sc_hd__inv_2_0/Y sky130_fd_sc_hd__dfrtp_1_3/a_805_47# VSUBS sky130_fd_pr__nfet_01v8 ad=-0p pd=-0u as=2e+08p ps=475000u w=420000u l=150000u
X136 sky130_fd_sc_hd__dfrtp_1_3/a_1108_47# sky130_fd_sc_hd__dfrtp_1_3/a_193_47# sky130_fd_sc_hd__dfrtp_1_3/a_761_289# VSUBS sky130_fd_pr__nfet_01v8 ad=0p pd=0u as=0p ps=0u w=360000u l=150000u
X137 sky130_fd_sc_hd__dfrtp_1_3/a_651_413# sky130_fd_sc_hd__inv_2_0/Y VSUBS VSUBS sky130_fd_pr__pfet_01v8_hvt ad=0p pd=0u as=-0p ps=-0u w=420000u l=150000u
X138 sky130_fd_sc_hd__dfrtp_1_3/a_193_47# sky130_fd_sc_hd__dfrtp_1_3/a_27_47# VSUBS VSUBS sky130_fd_pr__nfet_01v8 ad=2e+08p pd=470000u as=-0p ps=-0u w=420000u l=150000u
X139 VSUBS VSUBS sky130_fd_sc_hd__dfrtp_1_3/a_27_47# VSUBS sky130_fd_pr__nfet_01v8 ad=-0p pd=-0u as=0p ps=1.27315e+08u w=420000u l=150000u
X140 VSUBS VSUBS sky130_fd_sc_hd__dfrtp_1_3/a_27_47# VSUBS sky130_fd_pr__pfet_01v8_hvt ad=-0p pd=-0u as=0p ps=0u w=640000u l=150000u
X141 sky130_fd_sc_hd__ha_1_0/B sky130_fd_sc_hd__dfrtp_1_3/a_1283_21# VSUBS VSUBS sky130_fd_pr__pfet_01v8_hvt ad=0p pd=0u as=-0p ps=-0u w=1e+06u l=150000u
X142 sky130_fd_sc_hd__dfrtp_1_3/a_193_47# sky130_fd_sc_hd__dfrtp_1_3/a_27_47# VSUBS VSUBS sky130_fd_pr__pfet_01v8_hvt ad=0p pd=0u as=-0p ps=-0u w=640000u l=150000u
X143 VSUBS sky130_fd_sc_hd__dfrtp_1_3/a_1108_47# sky130_fd_sc_hd__dfrtp_1_3/a_1283_21# VSUBS sky130_fd_pr__pfet_01v8_hvt ad=-0p pd=-0u as=0p ps=0u w=420000u l=150000u
X144 sky130_fd_sc_hd__dfrtp_1_3/a_1462_47# sky130_fd_sc_hd__inv_2_0/Y VSUBS VSUBS sky130_fd_pr__nfet_01v8 ad=0p pd=0u as=-0p ps=-0u w=420000u l=150000u
X145 sky130_fd_sc_hd__dfrtp_1_3/a_448_47# sky130_fd_sc_hd__ha_1_0/SUM VSUBS VSUBS sky130_fd_pr__pfet_01v8_hvt ad=0p pd=0u as=-0p ps=-0u w=420000u l=150000u
X146 VSUBS sky130_fd_sc_hd__dfrtp_1_3/a_761_289# sky130_fd_sc_hd__dfrtp_1_3/a_651_413# VSUBS sky130_fd_pr__pfet_01v8_hvt ad=-0p pd=-0u as=0p ps=0u w=420000u l=150000u
X147 sky130_fd_sc_hd__dfrtp_1_3/a_1108_47# sky130_fd_sc_hd__dfrtp_1_3/a_27_47# sky130_fd_sc_hd__dfrtp_1_3/a_761_289# VSUBS sky130_fd_pr__pfet_01v8_hvt ad=0p pd=0u as=0p ps=0u w=420000u l=150000u
X148 sky130_fd_sc_hd__dfrtp_1_3/a_1283_21# sky130_fd_sc_hd__inv_2_0/Y VSUBS VSUBS sky130_fd_pr__pfet_01v8_hvt ad=0p pd=0u as=-0p ps=-0u w=420000u l=150000u
X149 sky130_fd_sc_hd__dfrtp_1_3/a_805_47# sky130_fd_sc_hd__dfrtp_1_3/a_761_289# sky130_fd_sc_hd__dfrtp_1_3/a_639_47# VSUBS sky130_fd_pr__nfet_01v8 ad=0p pd=0u as=0p ps=0u w=420000u l=150000u
X150 sky130_fd_sc_hd__xnor2_1_1/a_377_297# sky130_fd_sc_hd__buf_4_2/A VSUBS VSUBS sky130_fd_pr__pfet_01v8_hvt ad=-1.6384e+13p pd=-5000u as=-0p ps=-0u w=1e+06u l=150000u
X151 sky130_fd_sc_hd__xnor2_1_1/Y sky130_fd_sc_hd__xnor2_1_1/B sky130_fd_sc_hd__xnor2_1_1/a_377_297# VSUBS sky130_fd_pr__pfet_01v8_hvt ad=2.425e+09p pd=0u as=-0p ps=-0u w=1e+06u l=150000u
X152 VSUBS sky130_fd_sc_hd__xnor2_1_1/a_47_47# sky130_fd_sc_hd__xnor2_1_1/Y VSUBS sky130_fd_pr__pfet_01v8_hvt ad=-0p pd=-0u as=0p ps=0u w=1e+06u l=150000u
X153 VSUBS sky130_fd_sc_hd__buf_4_2/A sky130_fd_sc_hd__xnor2_1_1/a_129_47# VSUBS sky130_fd_pr__nfet_01v8 ad=-0p pd=-0u as=-1.6384e+13p ps=-5000u w=650000u l=150000u
X154 sky130_fd_sc_hd__xnor2_1_1/a_285_47# sky130_fd_sc_hd__xnor2_1_1/B VSUBS VSUBS sky130_fd_pr__nfet_01v8 ad=0p pd=0u as=-0p ps=-0u w=650000u l=150000u
X155 sky130_fd_sc_hd__xnor2_1_1/a_129_47# sky130_fd_sc_hd__xnor2_1_1/B sky130_fd_sc_hd__xnor2_1_1/a_47_47# VSUBS sky130_fd_pr__nfet_01v8 ad=-0p pd=-0u as=4.17126e+16p ps=8.00208e+12u w=650000u l=150000u
X156 sky130_fd_sc_hd__xnor2_1_1/a_47_47# sky130_fd_sc_hd__xnor2_1_1/B VSUBS VSUBS sky130_fd_pr__pfet_01v8_hvt ad=0p pd=0u as=-0p ps=-0u w=1e+06u l=150000u
X157 VSUBS sky130_fd_sc_hd__buf_4_2/A sky130_fd_sc_hd__xnor2_1_1/a_47_47# VSUBS sky130_fd_pr__pfet_01v8_hvt ad=-0p pd=-0u as=0p ps=0u w=1e+06u l=150000u
X158 sky130_fd_sc_hd__xnor2_1_1/a_285_47# sky130_fd_sc_hd__buf_4_2/A VSUBS VSUBS sky130_fd_pr__nfet_01v8 ad=0p pd=0u as=-0p ps=-0u w=650000u l=150000u
X159 sky130_fd_sc_hd__xnor2_1_1/Y sky130_fd_sc_hd__xnor2_1_1/a_47_47# sky130_fd_sc_hd__xnor2_1_1/a_285_47# VSUBS sky130_fd_pr__nfet_01v8 ad=0p pd=0u as=0p ps=0u w=650000u l=150000u
X160 count[0] sky130_fd_sc_hd__clkbuf_4_1/a_27_47# VSUBS VSUBS sky130_fd_pr__pfet_01v8_hvt ad=1e+09p pd=0u as=-0p ps=-0u w=1e+06u l=150000u
X161 VSUBS sky130_fd_sc_hd__clkbuf_4_1/a_27_47# count[0] VSUBS sky130_fd_pr__pfet_01v8_hvt ad=-0p pd=-0u as=0p ps=0u w=1e+06u l=150000u
X162 VSUBS sky130_fd_sc_hd__ha_1_0/A sky130_fd_sc_hd__clkbuf_4_1/a_27_47# VSUBS sky130_fd_pr__pfet_01v8_hvt ad=-0p pd=-0u as=2e+08p ps=480000u w=1e+06u l=150000u
X163 VSUBS sky130_fd_sc_hd__ha_1_0/A sky130_fd_sc_hd__clkbuf_4_1/a_27_47# VSUBS sky130_fd_pr__nfet_01v8 ad=-0p pd=-0u as=0p ps=0u w=420000u l=150000u
X164 VSUBS sky130_fd_sc_hd__clkbuf_4_1/a_27_47# count[0] VSUBS sky130_fd_pr__pfet_01v8_hvt ad=-0p pd=-0u as=0p ps=0u w=1e+06u l=150000u
X165 count[0] sky130_fd_sc_hd__clkbuf_4_1/a_27_47# VSUBS VSUBS sky130_fd_pr__nfet_01v8 ad=0p pd=0u as=-0p ps=-0u w=420000u l=150000u
X166 VSUBS sky130_fd_sc_hd__clkbuf_4_1/a_27_47# count[0] VSUBS sky130_fd_pr__nfet_01v8 ad=-0p pd=-0u as=0p ps=0u w=420000u l=150000u
X167 count[0] sky130_fd_sc_hd__clkbuf_4_1/a_27_47# VSUBS VSUBS sky130_fd_pr__nfet_01v8 ad=0p pd=0u as=-0p ps=-0u w=420000u l=150000u
X168 VSUBS sky130_fd_sc_hd__clkbuf_4_1/a_27_47# count[0] VSUBS sky130_fd_pr__nfet_01v8 ad=-0p pd=-0u as=0p ps=0u w=420000u l=150000u
X169 count[0] sky130_fd_sc_hd__clkbuf_4_1/a_27_47# VSUBS VSUBS sky130_fd_pr__pfet_01v8_hvt ad=0p pd=0u as=-0p ps=-0u w=1e+06u l=150000u
X170 VSUBS sky130_fd_sc_hd__dfrtp_1_4/a_1283_21# sky130_fd_sc_hd__dfrtp_1_4/a_1270_413# VSUBS sky130_fd_pr__pfet_01v8_hvt ad=-0p pd=-0u as=2e+08p ps=480000u w=420000u l=150000u
X171 sky130_fd_sc_hd__dfrtp_1_4/a_761_289# sky130_fd_sc_hd__dfrtp_1_4/a_543_47# VSUBS VSUBS sky130_fd_pr__pfet_01v8_hvt ad=8.192e+12p pd=0u as=-0p ps=-0u w=840000u l=150000u
X172 sky130_fd_sc_hd__dfrtp_1_4/a_761_289# sky130_fd_sc_hd__dfrtp_1_4/a_543_47# VSUBS VSUBS sky130_fd_pr__nfet_01v8 ad=0p pd=0u as=-0p ps=-0u w=640000u l=150000u
X173 sky130_fd_sc_hd__dfrtp_1_4/a_448_47# sky130_fd_sc_hd__xnor2_1_0/Y VSUBS VSUBS sky130_fd_pr__nfet_01v8 ad=0p pd=0u as=-0p ps=-0u w=420000u l=150000u
X174 sky130_fd_sc_hd__dfrtp_1_4/a_1270_413# sky130_fd_sc_hd__dfrtp_1_4/a_193_47# sky130_fd_sc_hd__dfrtp_1_4/a_1108_47# VSUBS sky130_fd_pr__pfet_01v8_hvt ad=0p pd=0u as=8.192e+12p ps=0u w=420000u l=150000u
X175 sky130_fd_sc_hd__buf_4_1/A sky130_fd_sc_hd__dfrtp_1_4/a_1283_21# VSUBS VSUBS sky130_fd_pr__nfet_01v8 ad=2.425e+09p pd=0u as=-0p ps=-0u w=650000u l=150000u
X176 VSUBS sky130_fd_sc_hd__dfrtp_1_4/a_1283_21# sky130_fd_sc_hd__dfrtp_1_4/a_1217_47# VSUBS sky130_fd_pr__nfet_01v8 ad=-0p pd=-0u as=2e+08p ps=480000u w=420000u l=150000u
X177 sky130_fd_sc_hd__dfrtp_1_4/a_543_47# sky130_fd_sc_hd__dfrtp_1_4/a_27_47# sky130_fd_sc_hd__dfrtp_1_4/a_448_47# VSUBS sky130_fd_pr__nfet_01v8 ad=8.192e+12p pd=0u as=0p ps=0u w=360000u l=150000u
X178 sky130_fd_sc_hd__dfrtp_1_4/a_543_47# sky130_fd_sc_hd__dfrtp_1_4/a_193_47# sky130_fd_sc_hd__dfrtp_1_4/a_448_47# VSUBS sky130_fd_pr__pfet_01v8_hvt ad=0p pd=0u as=0p ps=0u w=420000u l=150000u
X179 sky130_fd_sc_hd__dfrtp_1_4/a_639_47# sky130_fd_sc_hd__dfrtp_1_4/a_193_47# sky130_fd_sc_hd__dfrtp_1_4/a_543_47# VSUBS sky130_fd_pr__nfet_01v8 ad=0p pd=0u as=0p ps=0u w=360000u l=150000u
X180 sky130_fd_sc_hd__dfrtp_1_4/a_1217_47# sky130_fd_sc_hd__dfrtp_1_4/a_27_47# sky130_fd_sc_hd__dfrtp_1_4/a_1108_47# VSUBS sky130_fd_pr__nfet_01v8 ad=0p pd=0u as=0p ps=0u w=360000u l=150000u
X181 sky130_fd_sc_hd__dfrtp_1_4/a_1283_21# sky130_fd_sc_hd__dfrtp_1_4/a_1108_47# sky130_fd_sc_hd__dfrtp_1_4/a_1462_47# VSUBS sky130_fd_pr__nfet_01v8 ad=1.34218e+16p pd=0u as=6.6825e+10p ps=0u w=420000u l=150000u
X182 sky130_fd_sc_hd__dfrtp_1_4/a_651_413# sky130_fd_sc_hd__dfrtp_1_4/a_27_47# sky130_fd_sc_hd__dfrtp_1_4/a_543_47# VSUBS sky130_fd_pr__pfet_01v8_hvt ad=0p pd=0u as=0p ps=0u w=420000u l=150000u
X183 VSUBS sky130_fd_sc_hd__inv_2_0/Y sky130_fd_sc_hd__dfrtp_1_4/a_805_47# VSUBS sky130_fd_pr__nfet_01v8 ad=-0p pd=-0u as=1.34218e+16p ps=0u w=420000u l=150000u
X184 sky130_fd_sc_hd__dfrtp_1_4/a_1108_47# sky130_fd_sc_hd__dfrtp_1_4/a_193_47# sky130_fd_sc_hd__dfrtp_1_4/a_761_289# VSUBS sky130_fd_pr__nfet_01v8 ad=0p pd=0u as=0p ps=0u w=360000u l=150000u
X185 sky130_fd_sc_hd__dfrtp_1_4/a_651_413# sky130_fd_sc_hd__inv_2_0/Y VSUBS VSUBS sky130_fd_pr__pfet_01v8_hvt ad=0p pd=0u as=-0p ps=-0u w=420000u l=150000u
X186 sky130_fd_sc_hd__dfrtp_1_4/a_193_47# sky130_fd_sc_hd__dfrtp_1_4/a_27_47# VSUBS VSUBS sky130_fd_pr__nfet_01v8 ad=1.34218e+16p pd=0u as=-0p ps=-0u w=420000u l=150000u
X187 VSUBS sky130_fd_sc_hd__clkbuf_2_1/X sky130_fd_sc_hd__dfrtp_1_4/a_27_47# VSUBS sky130_fd_pr__nfet_01v8 ad=-0p pd=-0u as=2e+08p ps=480000u w=420000u l=150000u
X188 VSUBS sky130_fd_sc_hd__clkbuf_2_1/X sky130_fd_sc_hd__dfrtp_1_4/a_27_47# VSUBS sky130_fd_pr__pfet_01v8_hvt ad=-0p pd=-0u as=0p ps=0u w=640000u l=150000u
X189 sky130_fd_sc_hd__buf_4_1/A sky130_fd_sc_hd__dfrtp_1_4/a_1283_21# VSUBS VSUBS sky130_fd_pr__pfet_01v8_hvt ad=0p pd=0u as=-0p ps=-0u w=1e+06u l=150000u
X190 sky130_fd_sc_hd__dfrtp_1_4/a_193_47# sky130_fd_sc_hd__dfrtp_1_4/a_27_47# VSUBS VSUBS sky130_fd_pr__pfet_01v8_hvt ad=0p pd=0u as=-0p ps=-0u w=640000u l=150000u
X191 VSUBS sky130_fd_sc_hd__dfrtp_1_4/a_1108_47# sky130_fd_sc_hd__dfrtp_1_4/a_1283_21# VSUBS sky130_fd_pr__pfet_01v8_hvt ad=-0p pd=-0u as=0p ps=0u w=420000u l=150000u
X192 sky130_fd_sc_hd__dfrtp_1_4/a_1462_47# sky130_fd_sc_hd__inv_2_0/Y VSUBS VSUBS sky130_fd_pr__nfet_01v8 ad=0p pd=0u as=-0p ps=-0u w=420000u l=150000u
X193 sky130_fd_sc_hd__dfrtp_1_4/a_448_47# sky130_fd_sc_hd__xnor2_1_0/Y VSUBS VSUBS sky130_fd_pr__pfet_01v8_hvt ad=0p pd=0u as=-0p ps=-0u w=420000u l=150000u
X194 VSUBS sky130_fd_sc_hd__dfrtp_1_4/a_761_289# sky130_fd_sc_hd__dfrtp_1_4/a_651_413# VSUBS sky130_fd_pr__pfet_01v8_hvt ad=-0p pd=-0u as=0p ps=0u w=420000u l=150000u
X195 sky130_fd_sc_hd__dfrtp_1_4/a_1108_47# sky130_fd_sc_hd__dfrtp_1_4/a_27_47# sky130_fd_sc_hd__dfrtp_1_4/a_761_289# VSUBS sky130_fd_pr__pfet_01v8_hvt ad=0p pd=0u as=0p ps=0u w=420000u l=150000u
X196 sky130_fd_sc_hd__dfrtp_1_4/a_1283_21# sky130_fd_sc_hd__inv_2_0/Y VSUBS VSUBS sky130_fd_pr__pfet_01v8_hvt ad=0p pd=0u as=-0p ps=-0u w=420000u l=150000u
X197 sky130_fd_sc_hd__dfrtp_1_4/a_805_47# sky130_fd_sc_hd__dfrtp_1_4/a_761_289# sky130_fd_sc_hd__dfrtp_1_4/a_639_47# VSUBS sky130_fd_pr__nfet_01v8 ad=0p pd=0u as=0p ps=0u w=420000u l=150000u
X198 sky130_fd_sc_hd__xnor2_1_2/a_377_297# sky130_fd_sc_hd__xnor2_1_2/A VSUBS VSUBS sky130_fd_pr__pfet_01v8_hvt ad=-8.19203e+12p pd=-5000u as=-0p ps=-0u w=1e+06u l=150000u
X199 sky130_fd_sc_hd__xnor2_1_2/Y sky130_fd_sc_hd__xnor2_1_2/B sky130_fd_sc_hd__xnor2_1_2/a_377_297# VSUBS sky130_fd_pr__pfet_01v8_hvt ad=2e+08p pd=480000u as=-0p ps=-0u w=1e+06u l=150000u
X200 VSUBS sky130_fd_sc_hd__xnor2_1_2/a_47_47# sky130_fd_sc_hd__xnor2_1_2/Y VSUBS sky130_fd_pr__pfet_01v8_hvt ad=-0p pd=-0u as=0p ps=0u w=1e+06u l=150000u
X201 VSUBS sky130_fd_sc_hd__xnor2_1_2/A sky130_fd_sc_hd__xnor2_1_2/a_129_47# VSUBS sky130_fd_pr__nfet_01v8 ad=-0p pd=-0u as=-8.19203e+12p ps=-5000u w=650000u l=150000u
X202 sky130_fd_sc_hd__xnor2_1_2/a_285_47# sky130_fd_sc_hd__xnor2_1_2/B VSUBS VSUBS sky130_fd_pr__nfet_01v8 ad=1e+08p pd=-5000u as=-0p ps=-0u w=650000u l=150000u
X203 sky130_fd_sc_hd__xnor2_1_2/a_129_47# sky130_fd_sc_hd__xnor2_1_2/B sky130_fd_sc_hd__xnor2_1_2/a_47_47# VSUBS sky130_fd_pr__nfet_01v8 ad=-0p pd=-0u as=-4.19013e+14p ps=-5000u w=650000u l=150000u
X204 sky130_fd_sc_hd__xnor2_1_2/a_47_47# sky130_fd_sc_hd__xnor2_1_2/B VSUBS VSUBS sky130_fd_pr__pfet_01v8_hvt ad=-0p pd=-0u as=-0p ps=-0u w=1e+06u l=150000u
X205 VSUBS sky130_fd_sc_hd__xnor2_1_2/A sky130_fd_sc_hd__xnor2_1_2/a_47_47# VSUBS sky130_fd_pr__pfet_01v8_hvt ad=-0p pd=-0u as=-0p ps=-0u w=1e+06u l=150000u
X206 sky130_fd_sc_hd__xnor2_1_2/a_285_47# sky130_fd_sc_hd__xnor2_1_2/A VSUBS VSUBS sky130_fd_pr__nfet_01v8 ad=0p pd=-0u as=-0p ps=-0u w=650000u l=150000u
X207 sky130_fd_sc_hd__xnor2_1_2/Y sky130_fd_sc_hd__xnor2_1_2/a_47_47# sky130_fd_sc_hd__xnor2_1_2/a_285_47# VSUBS sky130_fd_pr__nfet_01v8 ad=0p pd=0u as=0p ps=-0u w=650000u l=150000u
X208 count[1] sky130_fd_sc_hd__clkbuf_4_2/a_27_47# VSUBS VSUBS sky130_fd_pr__pfet_01v8_hvt ad=9.2937e+12p pd=5.7299e+12u as=-0p ps=-0u w=1e+06u l=150000u
X209 VSUBS sky130_fd_sc_hd__clkbuf_4_2/a_27_47# count[1] VSUBS sky130_fd_pr__pfet_01v8_hvt ad=-0p pd=-0u as=0p ps=0u w=1e+06u l=150000u
X210 VSUBS sky130_fd_sc_hd__ha_1_0/B sky130_fd_sc_hd__clkbuf_4_2/a_27_47# VSUBS sky130_fd_pr__pfet_01v8_hvt ad=-0p pd=-0u as=-7.25e+08p ps=-5000u w=1e+06u l=150000u
X211 VSUBS sky130_fd_sc_hd__ha_1_0/B sky130_fd_sc_hd__clkbuf_4_2/a_27_47# VSUBS sky130_fd_pr__nfet_01v8 ad=-0p pd=-0u as=-0p ps=-0u w=420000u l=150000u
X212 VSUBS sky130_fd_sc_hd__clkbuf_4_2/a_27_47# count[1] VSUBS sky130_fd_pr__pfet_01v8_hvt ad=-0p pd=-0u as=0p ps=0u w=1e+06u l=150000u
X213 count[1] sky130_fd_sc_hd__clkbuf_4_2/a_27_47# VSUBS VSUBS sky130_fd_pr__nfet_01v8 ad=0p pd=0u as=-0p ps=-0u w=420000u l=150000u
X214 VSUBS sky130_fd_sc_hd__clkbuf_4_2/a_27_47# count[1] VSUBS sky130_fd_pr__nfet_01v8 ad=-0p pd=-0u as=0p ps=0u w=420000u l=150000u
X215 count[1] sky130_fd_sc_hd__clkbuf_4_2/a_27_47# VSUBS VSUBS sky130_fd_pr__nfet_01v8 ad=0p pd=0u as=-0p ps=-0u w=420000u l=150000u
X216 VSUBS sky130_fd_sc_hd__clkbuf_4_2/a_27_47# count[1] VSUBS sky130_fd_pr__nfet_01v8 ad=-0p pd=-0u as=0p ps=0u w=420000u l=150000u
X217 count[1] sky130_fd_sc_hd__clkbuf_4_2/a_27_47# VSUBS VSUBS sky130_fd_pr__pfet_01v8_hvt ad=0p pd=0u as=-0p ps=-0u w=1e+06u l=150000u
X218 VSUBS sky130_fd_sc_hd__dfrtp_1_5/a_1283_21# sky130_fd_sc_hd__dfrtp_1_5/a_1270_413# VSUBS sky130_fd_pr__pfet_01v8_hvt ad=-0p pd=-0u as=0p ps=0u w=420000u l=150000u
X219 sky130_fd_sc_hd__dfrtp_1_5/a_761_289# sky130_fd_sc_hd__dfrtp_1_5/a_543_47# VSUBS VSUBS sky130_fd_pr__pfet_01v8_hvt ad=2.75e+08p pd=0u as=-0p ps=-0u w=840000u l=150000u
X220 sky130_fd_sc_hd__dfrtp_1_5/a_761_289# sky130_fd_sc_hd__dfrtp_1_5/a_543_47# VSUBS VSUBS sky130_fd_pr__nfet_01v8 ad=0p pd=0u as=-0p ps=-0u w=640000u l=150000u
X221 sky130_fd_sc_hd__dfrtp_1_5/a_448_47# sky130_fd_sc_hd__xor2_1_1/X VSUBS VSUBS sky130_fd_pr__nfet_01v8 ad=0p pd=0u as=-0p ps=-0u w=420000u l=150000u
X222 sky130_fd_sc_hd__dfrtp_1_5/a_1270_413# sky130_fd_sc_hd__dfrtp_1_5/a_193_47# sky130_fd_sc_hd__dfrtp_1_5/a_1108_47# VSUBS sky130_fd_pr__pfet_01v8_hvt ad=0p pd=0u as=2.425e+09p ps=0u w=420000u l=150000u
X223 VSUBS sky130_fd_sc_hd__dfrtp_1_5/a_1283_21# VSUBS VSUBS sky130_fd_pr__nfet_01v8 ad=-0p pd=-0u as=-0p ps=-0u w=650000u l=150000u
X224 VSUBS sky130_fd_sc_hd__dfrtp_1_5/a_1283_21# sky130_fd_sc_hd__dfrtp_1_5/a_1217_47# VSUBS sky130_fd_pr__nfet_01v8 ad=-0p pd=-0u as=1.67772e+15p ps=0u w=420000u l=150000u
X225 sky130_fd_sc_hd__dfrtp_1_5/a_543_47# sky130_fd_sc_hd__dfrtp_1_5/a_27_47# sky130_fd_sc_hd__dfrtp_1_5/a_448_47# VSUBS sky130_fd_pr__nfet_01v8 ad=2e+08p pd=820000u as=0p ps=0u w=360000u l=150000u
X226 sky130_fd_sc_hd__dfrtp_1_5/a_543_47# sky130_fd_sc_hd__dfrtp_1_5/a_193_47# sky130_fd_sc_hd__dfrtp_1_5/a_448_47# VSUBS sky130_fd_pr__pfet_01v8_hvt ad=0p pd=0u as=0p ps=0u w=420000u l=150000u
X227 sky130_fd_sc_hd__dfrtp_1_5/a_639_47# sky130_fd_sc_hd__dfrtp_1_5/a_193_47# sky130_fd_sc_hd__dfrtp_1_5/a_543_47# VSUBS sky130_fd_pr__nfet_01v8 ad=2.425e+09p pd=0u as=0p ps=0u w=360000u l=150000u
X228 sky130_fd_sc_hd__dfrtp_1_5/a_1217_47# sky130_fd_sc_hd__dfrtp_1_5/a_27_47# sky130_fd_sc_hd__dfrtp_1_5/a_1108_47# VSUBS sky130_fd_pr__nfet_01v8 ad=0p pd=0u as=0p ps=0u w=360000u l=150000u
X229 sky130_fd_sc_hd__dfrtp_1_5/a_1283_21# sky130_fd_sc_hd__dfrtp_1_5/a_1108_47# sky130_fd_sc_hd__dfrtp_1_5/a_1462_47# VSUBS sky130_fd_pr__nfet_01v8 ad=2e+08p pd=0u as=0p ps=0u w=420000u l=150000u
X230 sky130_fd_sc_hd__dfrtp_1_5/a_651_413# sky130_fd_sc_hd__dfrtp_1_5/a_27_47# sky130_fd_sc_hd__dfrtp_1_5/a_543_47# VSUBS sky130_fd_pr__pfet_01v8_hvt ad=2.8e+09p pd=0u as=0p ps=0u w=420000u l=150000u
X231 VSUBS sky130_fd_sc_hd__inv_2_0/Y sky130_fd_sc_hd__dfrtp_1_5/a_805_47# VSUBS sky130_fd_pr__nfet_01v8 ad=-0p pd=-0u as=2e+08p ps=0u w=420000u l=150000u
X232 sky130_fd_sc_hd__dfrtp_1_5/a_1108_47# sky130_fd_sc_hd__dfrtp_1_5/a_193_47# sky130_fd_sc_hd__dfrtp_1_5/a_761_289# VSUBS sky130_fd_pr__nfet_01v8 ad=0p pd=0u as=0p ps=0u w=360000u l=150000u
X233 sky130_fd_sc_hd__dfrtp_1_5/a_651_413# sky130_fd_sc_hd__inv_2_0/Y VSUBS VSUBS sky130_fd_pr__pfet_01v8_hvt ad=0p pd=0u as=-0p ps=-0u w=420000u l=150000u
X234 sky130_fd_sc_hd__dfrtp_1_5/a_193_47# sky130_fd_sc_hd__dfrtp_1_5/a_27_47# VSUBS VSUBS sky130_fd_pr__nfet_01v8 ad=1.67771e+15p pd=0u as=-0p ps=-0u w=420000u l=150000u
X235 VSUBS sky130_fd_sc_hd__clkbuf_2_1/X sky130_fd_sc_hd__dfrtp_1_5/a_27_47# VSUBS sky130_fd_pr__nfet_01v8 ad=-0p pd=-0u as=0p ps=25000u w=420000u l=150000u
X236 VSUBS sky130_fd_sc_hd__clkbuf_2_1/X sky130_fd_sc_hd__dfrtp_1_5/a_27_47# VSUBS sky130_fd_pr__pfet_01v8_hvt ad=-0p pd=-0u as=0p ps=0u w=640000u l=150000u
X237 VSUBS sky130_fd_sc_hd__dfrtp_1_5/a_1283_21# VSUBS VSUBS sky130_fd_pr__pfet_01v8_hvt ad=-0p pd=-0u as=-0p ps=-0u w=1e+06u l=150000u
X238 sky130_fd_sc_hd__dfrtp_1_5/a_193_47# sky130_fd_sc_hd__dfrtp_1_5/a_27_47# VSUBS VSUBS sky130_fd_pr__pfet_01v8_hvt ad=0p pd=0u as=-0p ps=-0u w=640000u l=150000u
X239 VSUBS sky130_fd_sc_hd__dfrtp_1_5/a_1108_47# sky130_fd_sc_hd__dfrtp_1_5/a_1283_21# VSUBS sky130_fd_pr__pfet_01v8_hvt ad=-0p pd=-0u as=0p ps=0u w=420000u l=150000u
X240 sky130_fd_sc_hd__dfrtp_1_5/a_1462_47# sky130_fd_sc_hd__inv_2_0/Y VSUBS VSUBS sky130_fd_pr__nfet_01v8 ad=0p pd=0u as=-0p ps=-0u w=420000u l=150000u
X241 sky130_fd_sc_hd__dfrtp_1_5/a_448_47# sky130_fd_sc_hd__xor2_1_1/X VSUBS VSUBS sky130_fd_pr__pfet_01v8_hvt ad=0p pd=0u as=-0p ps=-0u w=420000u l=150000u
X242 VSUBS sky130_fd_sc_hd__dfrtp_1_5/a_761_289# sky130_fd_sc_hd__dfrtp_1_5/a_651_413# VSUBS sky130_fd_pr__pfet_01v8_hvt ad=-0p pd=-0u as=0p ps=0u w=420000u l=150000u
X243 sky130_fd_sc_hd__dfrtp_1_5/a_1108_47# sky130_fd_sc_hd__dfrtp_1_5/a_27_47# sky130_fd_sc_hd__dfrtp_1_5/a_761_289# VSUBS sky130_fd_pr__pfet_01v8_hvt ad=0p pd=0u as=0p ps=0u w=420000u l=150000u
X244 sky130_fd_sc_hd__dfrtp_1_5/a_1283_21# sky130_fd_sc_hd__inv_2_0/Y VSUBS VSUBS sky130_fd_pr__pfet_01v8_hvt ad=0p pd=0u as=-0p ps=-0u w=420000u l=150000u
X245 sky130_fd_sc_hd__dfrtp_1_5/a_805_47# sky130_fd_sc_hd__dfrtp_1_5/a_761_289# sky130_fd_sc_hd__dfrtp_1_5/a_639_47# VSUBS sky130_fd_pr__nfet_01v8 ad=0p pd=0u as=0p ps=0u w=420000u l=150000u
X246 count[6] sky130_fd_sc_hd__clkbuf_4_3/a_27_47# VSUBS VSUBS sky130_fd_pr__pfet_01v8_hvt ad=0p pd=0u as=-0p ps=-0u w=1e+06u l=150000u
X247 VSUBS sky130_fd_sc_hd__clkbuf_4_3/a_27_47# count[6] VSUBS sky130_fd_pr__pfet_01v8_hvt ad=-0p pd=-0u as=0p ps=0u w=1e+06u l=150000u
X248 VSUBS VSUBS sky130_fd_sc_hd__clkbuf_4_3/a_27_47# VSUBS sky130_fd_pr__pfet_01v8_hvt ad=-0p pd=-0u as=2.425e+09p ps=0u w=1e+06u l=150000u
X249 VSUBS VSUBS sky130_fd_sc_hd__clkbuf_4_3/a_27_47# VSUBS sky130_fd_pr__nfet_01v8 ad=-0p pd=-0u as=0p ps=0u w=420000u l=150000u
X250 VSUBS sky130_fd_sc_hd__clkbuf_4_3/a_27_47# count[6] VSUBS sky130_fd_pr__pfet_01v8_hvt ad=-0p pd=-0u as=0p ps=0u w=1e+06u l=150000u
X251 count[6] sky130_fd_sc_hd__clkbuf_4_3/a_27_47# VSUBS VSUBS sky130_fd_pr__nfet_01v8 ad=0p pd=0u as=-0p ps=-0u w=420000u l=150000u
X252 VSUBS sky130_fd_sc_hd__clkbuf_4_3/a_27_47# count[6] VSUBS sky130_fd_pr__nfet_01v8 ad=-0p pd=-0u as=0p ps=0u w=420000u l=150000u
X253 count[6] sky130_fd_sc_hd__clkbuf_4_3/a_27_47# VSUBS VSUBS sky130_fd_pr__nfet_01v8 ad=0p pd=0u as=-0p ps=-0u w=420000u l=150000u
X254 VSUBS sky130_fd_sc_hd__clkbuf_4_3/a_27_47# count[6] VSUBS sky130_fd_pr__nfet_01v8 ad=-0p pd=-0u as=0p ps=0u w=420000u l=150000u
X255 count[6] sky130_fd_sc_hd__clkbuf_4_3/a_27_47# VSUBS VSUBS sky130_fd_pr__pfet_01v8_hvt ad=0p pd=0u as=-0p ps=-0u w=1e+06u l=150000u
X256 VSUBS sky130_fd_sc_hd__clkbuf_2_2/X sky130_fd_sc_hd__clkbuf_2_0/a_27_47# VSUBS sky130_fd_pr__pfet_01v8_hvt ad=-0p pd=-0u as=2e+08p ps=0u w=1e+06u l=150000u
X257 VSUBS sky130_fd_sc_hd__clkbuf_2_2/X sky130_fd_sc_hd__clkbuf_2_0/a_27_47# VSUBS sky130_fd_pr__nfet_01v8 ad=-0p pd=-0u as=0p ps=0u w=420000u l=150000u
X258 VSUBS sky130_fd_sc_hd__clkbuf_2_0/a_27_47# VSUBS VSUBS sky130_fd_pr__pfet_01v8_hvt ad=-0p pd=-0u as=-0p ps=-0u w=1e+06u l=150000u
X259 VSUBS sky130_fd_sc_hd__clkbuf_2_0/a_27_47# VSUBS VSUBS sky130_fd_pr__pfet_01v8_hvt ad=-0p pd=-0u as=-0p ps=-0u w=1e+06u l=150000u
X260 VSUBS sky130_fd_sc_hd__clkbuf_2_0/a_27_47# VSUBS VSUBS sky130_fd_pr__nfet_01v8 ad=-0p pd=-0u as=-0p ps=-0u w=420000u l=150000u
X261 VSUBS sky130_fd_sc_hd__clkbuf_2_0/a_27_47# VSUBS VSUBS sky130_fd_pr__nfet_01v8 ad=-0p pd=-0u as=-0p ps=-0u w=420000u l=150000u
X262 VSUBS sky130_fd_sc_hd__buf_4_0/a_27_47# count[7] VSUBS sky130_fd_pr__nfet_01v8 ad=-0p pd=-0u as=0p ps=0u w=650000u l=150000u
X263 count[7] sky130_fd_sc_hd__buf_4_0/a_27_47# VSUBS VSUBS sky130_fd_pr__nfet_01v8 ad=0p pd=0u as=-0p ps=-0u w=650000u l=150000u
X264 VSUBS sky130_fd_sc_hd__buf_4_0/a_27_47# count[7] VSUBS sky130_fd_pr__nfet_01v8 ad=-0p pd=-0u as=0p ps=0u w=650000u l=150000u
X265 count[7] sky130_fd_sc_hd__buf_4_0/a_27_47# VSUBS VSUBS sky130_fd_pr__nfet_01v8 ad=0p pd=0u as=-0p ps=-0u w=650000u l=150000u
X266 VSUBS sky130_fd_sc_hd__buf_4_0/a_27_47# count[7] VSUBS sky130_fd_pr__pfet_01v8_hvt ad=-0p pd=-0u as=0p ps=0u w=1e+06u l=150000u
X267 VSUBS sky130_fd_sc_hd__buf_4_0/A sky130_fd_sc_hd__buf_4_0/a_27_47# VSUBS sky130_fd_pr__nfet_01v8 ad=-0p pd=-0u as=1.67771e+15p ps=0u w=650000u l=150000u
X268 VSUBS sky130_fd_sc_hd__buf_4_0/a_27_47# count[7] VSUBS sky130_fd_pr__pfet_01v8_hvt ad=-0p pd=-0u as=0p ps=0u w=1e+06u l=150000u
X269 VSUBS sky130_fd_sc_hd__buf_4_0/A sky130_fd_sc_hd__buf_4_0/a_27_47# VSUBS sky130_fd_pr__pfet_01v8_hvt ad=-0p pd=-0u as=0p ps=0u w=1e+06u l=150000u
X270 count[7] sky130_fd_sc_hd__buf_4_0/a_27_47# VSUBS VSUBS sky130_fd_pr__pfet_01v8_hvt ad=0p pd=0u as=-0p ps=-0u w=1e+06u l=150000u
X271 count[7] sky130_fd_sc_hd__buf_4_0/a_27_47# VSUBS VSUBS sky130_fd_pr__pfet_01v8_hvt ad=0p pd=0u as=-0p ps=-0u w=1e+06u l=150000u
X272 VSUBS sky130_fd_sc_hd__dfrtp_1_6/a_1283_21# sky130_fd_sc_hd__dfrtp_1_6/a_1270_413# VSUBS sky130_fd_pr__pfet_01v8_hvt ad=-0p pd=-0u as=9.61485e+14p ps=0u w=420000u l=150000u
X273 sky130_fd_sc_hd__dfrtp_1_6/a_761_289# sky130_fd_sc_hd__dfrtp_1_6/a_543_47# VSUBS VSUBS sky130_fd_pr__pfet_01v8_hvt ad=2.425e+09p pd=0u as=-0p ps=-0u w=840000u l=150000u
X274 sky130_fd_sc_hd__dfrtp_1_6/a_761_289# sky130_fd_sc_hd__dfrtp_1_6/a_543_47# VSUBS VSUBS sky130_fd_pr__nfet_01v8 ad=0p pd=0u as=-0p ps=-0u w=640000u l=150000u
X275 sky130_fd_sc_hd__dfrtp_1_6/a_448_47# sky130_fd_sc_hd__xor2_1_2/X VSUBS VSUBS sky130_fd_pr__nfet_01v8 ad=0p pd=0u as=-0p ps=-0u w=420000u l=150000u
X276 sky130_fd_sc_hd__dfrtp_1_6/a_1270_413# sky130_fd_sc_hd__dfrtp_1_6/a_193_47# sky130_fd_sc_hd__dfrtp_1_6/a_1108_47# VSUBS sky130_fd_pr__pfet_01v8_hvt ad=0p pd=0u as=0p ps=0u w=420000u l=150000u
X277 VSUBS sky130_fd_sc_hd__dfrtp_1_6/a_1283_21# VSUBS VSUBS sky130_fd_pr__nfet_01v8 ad=-0p pd=-0u as=-0p ps=-0u w=650000u l=150000u
X278 VSUBS sky130_fd_sc_hd__dfrtp_1_6/a_1283_21# sky130_fd_sc_hd__dfrtp_1_6/a_1217_47# VSUBS sky130_fd_pr__nfet_01v8 ad=-0p pd=-0u as=2e+08p ps=0u w=420000u l=150000u
X279 sky130_fd_sc_hd__dfrtp_1_6/a_543_47# sky130_fd_sc_hd__dfrtp_1_6/a_27_47# sky130_fd_sc_hd__dfrtp_1_6/a_448_47# VSUBS sky130_fd_pr__nfet_01v8 ad=2e+08p pd=0u as=0p ps=0u w=360000u l=150000u
X280 sky130_fd_sc_hd__dfrtp_1_6/a_543_47# sky130_fd_sc_hd__dfrtp_1_6/a_193_47# sky130_fd_sc_hd__dfrtp_1_6/a_448_47# VSUBS sky130_fd_pr__pfet_01v8_hvt ad=0p pd=0u as=0p ps=0u w=420000u l=150000u
X281 sky130_fd_sc_hd__dfrtp_1_6/a_639_47# sky130_fd_sc_hd__dfrtp_1_6/a_193_47# sky130_fd_sc_hd__dfrtp_1_6/a_543_47# VSUBS sky130_fd_pr__nfet_01v8 ad=-1.88621e+14p pd=5000u as=0p ps=0u w=360000u l=150000u
X282 sky130_fd_sc_hd__dfrtp_1_6/a_1217_47# sky130_fd_sc_hd__dfrtp_1_6/a_27_47# sky130_fd_sc_hd__dfrtp_1_6/a_1108_47# VSUBS sky130_fd_pr__nfet_01v8 ad=0p pd=0u as=0p ps=0u w=360000u l=150000u
X283 sky130_fd_sc_hd__dfrtp_1_6/a_1283_21# sky130_fd_sc_hd__dfrtp_1_6/a_1108_47# sky130_fd_sc_hd__dfrtp_1_6/a_1462_47# VSUBS sky130_fd_pr__nfet_01v8 ad=2.425e+09p pd=0u as=2.25e+08p ps=0u w=420000u l=150000u
X284 sky130_fd_sc_hd__dfrtp_1_6/a_651_413# sky130_fd_sc_hd__dfrtp_1_6/a_27_47# sky130_fd_sc_hd__dfrtp_1_6/a_543_47# VSUBS sky130_fd_pr__pfet_01v8_hvt ad=2e+08p pd=0u as=0p ps=0u w=420000u l=150000u
X285 VSUBS sky130_fd_sc_hd__inv_2_0/Y sky130_fd_sc_hd__dfrtp_1_6/a_805_47# VSUBS sky130_fd_pr__nfet_01v8 ad=-0p pd=-0u as=0p ps=0u w=420000u l=150000u
X286 sky130_fd_sc_hd__dfrtp_1_6/a_1108_47# sky130_fd_sc_hd__dfrtp_1_6/a_193_47# sky130_fd_sc_hd__dfrtp_1_6/a_761_289# VSUBS sky130_fd_pr__nfet_01v8 ad=0p pd=0u as=0p ps=0u w=360000u l=150000u
X287 sky130_fd_sc_hd__dfrtp_1_6/a_651_413# sky130_fd_sc_hd__inv_2_0/Y VSUBS VSUBS sky130_fd_pr__pfet_01v8_hvt ad=0p pd=0u as=-0p ps=-0u w=420000u l=150000u
X288 sky130_fd_sc_hd__dfrtp_1_6/a_193_47# sky130_fd_sc_hd__dfrtp_1_6/a_27_47# VSUBS VSUBS sky130_fd_pr__nfet_01v8 ad=1.3575e+10p pd=0u as=-0p ps=-0u w=420000u l=150000u
X289 VSUBS VSUBS sky130_fd_sc_hd__dfrtp_1_6/a_27_47# VSUBS sky130_fd_pr__nfet_01v8 ad=-0p pd=-0u as=2e+08p ps=2.68435e+12u w=420000u l=150000u
X290 VSUBS VSUBS sky130_fd_sc_hd__dfrtp_1_6/a_27_47# VSUBS sky130_fd_pr__pfet_01v8_hvt ad=-0p pd=-0u as=0p ps=0u w=640000u l=150000u
X291 VSUBS sky130_fd_sc_hd__dfrtp_1_6/a_1283_21# VSUBS VSUBS sky130_fd_pr__pfet_01v8_hvt ad=-0p pd=-0u as=-0p ps=-0u w=1e+06u l=150000u
X292 sky130_fd_sc_hd__dfrtp_1_6/a_193_47# sky130_fd_sc_hd__dfrtp_1_6/a_27_47# VSUBS VSUBS sky130_fd_pr__pfet_01v8_hvt ad=0p pd=0u as=-0p ps=-0u w=640000u l=150000u
X293 VSUBS sky130_fd_sc_hd__dfrtp_1_6/a_1108_47# sky130_fd_sc_hd__dfrtp_1_6/a_1283_21# VSUBS sky130_fd_pr__pfet_01v8_hvt ad=-0p pd=-0u as=0p ps=0u w=420000u l=150000u
X294 sky130_fd_sc_hd__dfrtp_1_6/a_1462_47# sky130_fd_sc_hd__inv_2_0/Y VSUBS VSUBS sky130_fd_pr__nfet_01v8 ad=0p pd=0u as=-0p ps=-0u w=420000u l=150000u
X295 sky130_fd_sc_hd__dfrtp_1_6/a_448_47# sky130_fd_sc_hd__xor2_1_2/X VSUBS VSUBS sky130_fd_pr__pfet_01v8_hvt ad=0p pd=0u as=-0p ps=-0u w=420000u l=150000u
X296 VSUBS sky130_fd_sc_hd__dfrtp_1_6/a_761_289# sky130_fd_sc_hd__dfrtp_1_6/a_651_413# VSUBS sky130_fd_pr__pfet_01v8_hvt ad=-0p pd=-0u as=0p ps=0u w=420000u l=150000u
X297 sky130_fd_sc_hd__dfrtp_1_6/a_1108_47# sky130_fd_sc_hd__dfrtp_1_6/a_27_47# sky130_fd_sc_hd__dfrtp_1_6/a_761_289# VSUBS sky130_fd_pr__pfet_01v8_hvt ad=0p pd=0u as=0p ps=0u w=420000u l=150000u
X298 sky130_fd_sc_hd__dfrtp_1_6/a_1283_21# sky130_fd_sc_hd__inv_2_0/Y VSUBS VSUBS sky130_fd_pr__pfet_01v8_hvt ad=0p pd=0u as=-0p ps=-0u w=420000u l=150000u
X299 sky130_fd_sc_hd__dfrtp_1_6/a_805_47# sky130_fd_sc_hd__dfrtp_1_6/a_761_289# sky130_fd_sc_hd__dfrtp_1_6/a_639_47# VSUBS sky130_fd_pr__nfet_01v8 ad=0p pd=0u as=-0p ps=0u w=420000u l=150000u
X300 VSUBS sky130_fd_sc_hd__clkbuf_2_2/X sky130_fd_sc_hd__clkbuf_2_1/a_27_47# VSUBS sky130_fd_pr__pfet_01v8_hvt ad=-0p pd=-0u as=2e+08p ps=0u w=1e+06u l=150000u
X301 VSUBS sky130_fd_sc_hd__clkbuf_2_2/X sky130_fd_sc_hd__clkbuf_2_1/a_27_47# VSUBS sky130_fd_pr__nfet_01v8 ad=-0p pd=-0u as=0p ps=0u w=420000u l=150000u
X302 VSUBS sky130_fd_sc_hd__clkbuf_2_1/a_27_47# sky130_fd_sc_hd__clkbuf_2_1/X VSUBS sky130_fd_pr__pfet_01v8_hvt ad=-0p pd=-0u as=0p ps=0u w=1e+06u l=150000u
X303 sky130_fd_sc_hd__clkbuf_2_1/X sky130_fd_sc_hd__clkbuf_2_1/a_27_47# VSUBS VSUBS sky130_fd_pr__pfet_01v8_hvt ad=0p pd=0u as=-0p ps=-0u w=1e+06u l=150000u
X304 VSUBS sky130_fd_sc_hd__clkbuf_2_1/a_27_47# sky130_fd_sc_hd__clkbuf_2_1/X VSUBS sky130_fd_pr__nfet_01v8 ad=-0p pd=-0u as=0p ps=0u w=420000u l=150000u
X305 sky130_fd_sc_hd__clkbuf_2_1/X sky130_fd_sc_hd__clkbuf_2_1/a_27_47# VSUBS VSUBS sky130_fd_pr__nfet_01v8 ad=0p pd=0u as=-0p ps=-0u w=420000u l=150000u
X306 VSUBS sky130_fd_sc_hd__buf_4_1/a_27_47# count[4] VSUBS sky130_fd_pr__nfet_01v8 ad=-0p pd=-0u as=2.825e+09p ps=0u w=650000u l=150000u
X307 count[4] sky130_fd_sc_hd__buf_4_1/a_27_47# VSUBS VSUBS sky130_fd_pr__nfet_01v8 ad=0p pd=0u as=-0p ps=-0u w=650000u l=150000u
X308 VSUBS sky130_fd_sc_hd__buf_4_1/a_27_47# count[4] VSUBS sky130_fd_pr__nfet_01v8 ad=-0p pd=-0u as=0p ps=0u w=650000u l=150000u
X309 count[4] sky130_fd_sc_hd__buf_4_1/a_27_47# VSUBS VSUBS sky130_fd_pr__nfet_01v8 ad=0p pd=0u as=-0p ps=-0u w=650000u l=150000u
X310 VSUBS sky130_fd_sc_hd__buf_4_1/a_27_47# count[4] VSUBS sky130_fd_pr__pfet_01v8_hvt ad=-0p pd=-0u as=0p ps=0u w=1e+06u l=150000u
X311 VSUBS sky130_fd_sc_hd__buf_4_1/A sky130_fd_sc_hd__buf_4_1/a_27_47# VSUBS sky130_fd_pr__nfet_01v8 ad=-0p pd=-0u as=0p ps=0u w=650000u l=150000u
X312 VSUBS sky130_fd_sc_hd__buf_4_1/a_27_47# count[4] VSUBS sky130_fd_pr__pfet_01v8_hvt ad=-0p pd=-0u as=0p ps=0u w=1e+06u l=150000u
X313 VSUBS sky130_fd_sc_hd__buf_4_1/A sky130_fd_sc_hd__buf_4_1/a_27_47# VSUBS sky130_fd_pr__pfet_01v8_hvt ad=-0p pd=-0u as=0p ps=0u w=1e+06u l=150000u
X314 count[4] sky130_fd_sc_hd__buf_4_1/a_27_47# VSUBS VSUBS sky130_fd_pr__pfet_01v8_hvt ad=0p pd=0u as=-0p ps=-0u w=1e+06u l=150000u
X315 count[4] sky130_fd_sc_hd__buf_4_1/a_27_47# VSUBS VSUBS sky130_fd_pr__pfet_01v8_hvt ad=0p pd=0u as=-0p ps=-0u w=1e+06u l=150000u
X316 VSUBS sky130_fd_sc_hd__dfrtp_1_7/a_1283_21# sky130_fd_sc_hd__dfrtp_1_7/a_1270_413# VSUBS sky130_fd_pr__pfet_01v8_hvt ad=-0p pd=-0u as=-2.5e+07p ps=-5000u w=420000u l=150000u
X317 sky130_fd_sc_hd__dfrtp_1_7/a_761_289# sky130_fd_sc_hd__dfrtp_1_7/a_543_47# VSUBS VSUBS sky130_fd_pr__pfet_01v8_hvt ad=1.67771e+15p pd=0u as=-0p ps=-0u w=840000u l=150000u
X318 sky130_fd_sc_hd__dfrtp_1_7/a_761_289# sky130_fd_sc_hd__dfrtp_1_7/a_543_47# VSUBS VSUBS sky130_fd_pr__nfet_01v8 ad=0p pd=0u as=-0p ps=-0u w=640000u l=150000u
X319 sky130_fd_sc_hd__dfrtp_1_7/a_448_47# sky130_fd_sc_hd__xnor2_1_1/Y VSUBS VSUBS sky130_fd_pr__nfet_01v8 ad=2e+08p pd=0u as=-0p ps=-0u w=420000u l=150000u
X320 sky130_fd_sc_hd__dfrtp_1_7/a_1270_413# sky130_fd_sc_hd__dfrtp_1_7/a_193_47# sky130_fd_sc_hd__dfrtp_1_7/a_1108_47# VSUBS sky130_fd_pr__pfet_01v8_hvt ad=-0p pd=-0u as=0p ps=0u w=420000u l=150000u
X321 sky130_fd_sc_hd__buf_4_2/A sky130_fd_sc_hd__dfrtp_1_7/a_1283_21# VSUBS VSUBS sky130_fd_pr__nfet_01v8 ad=6.936e+11p pd=0u as=-0p ps=-0u w=650000u l=150000u
X322 VSUBS sky130_fd_sc_hd__dfrtp_1_7/a_1283_21# sky130_fd_sc_hd__dfrtp_1_7/a_1217_47# VSUBS sky130_fd_pr__nfet_01v8 ad=-0p pd=-0u as=0p ps=0u w=420000u l=150000u
X323 sky130_fd_sc_hd__dfrtp_1_7/a_543_47# sky130_fd_sc_hd__dfrtp_1_7/a_27_47# sky130_fd_sc_hd__dfrtp_1_7/a_448_47# VSUBS sky130_fd_pr__nfet_01v8 ad=1.54665e+15p pd=0u as=0p ps=0u w=360000u l=150000u
X324 sky130_fd_sc_hd__dfrtp_1_7/a_543_47# sky130_fd_sc_hd__dfrtp_1_7/a_193_47# sky130_fd_sc_hd__dfrtp_1_7/a_448_47# VSUBS sky130_fd_pr__pfet_01v8_hvt ad=0p pd=0u as=0p ps=0u w=420000u l=150000u
X325 sky130_fd_sc_hd__dfrtp_1_7/a_639_47# sky130_fd_sc_hd__dfrtp_1_7/a_193_47# sky130_fd_sc_hd__dfrtp_1_7/a_543_47# VSUBS sky130_fd_pr__nfet_01v8 ad=3.2e+09p pd=0u as=0p ps=0u w=360000u l=150000u
X326 sky130_fd_sc_hd__dfrtp_1_7/a_1217_47# sky130_fd_sc_hd__dfrtp_1_7/a_27_47# sky130_fd_sc_hd__dfrtp_1_7/a_1108_47# VSUBS sky130_fd_pr__nfet_01v8 ad=0p pd=0u as=0p ps=0u w=360000u l=150000u
X327 sky130_fd_sc_hd__dfrtp_1_7/a_1283_21# sky130_fd_sc_hd__dfrtp_1_7/a_1108_47# sky130_fd_sc_hd__dfrtp_1_7/a_1462_47# VSUBS sky130_fd_pr__nfet_01v8 ad=1.29e+10p pd=0u as=0p ps=0u w=420000u l=150000u
X328 sky130_fd_sc_hd__dfrtp_1_7/a_651_413# sky130_fd_sc_hd__dfrtp_1_7/a_27_47# sky130_fd_sc_hd__dfrtp_1_7/a_543_47# VSUBS sky130_fd_pr__pfet_01v8_hvt ad=2.425e+09p pd=0u as=0p ps=0u w=420000u l=150000u
X329 VSUBS sky130_fd_sc_hd__inv_2_0/Y sky130_fd_sc_hd__dfrtp_1_7/a_805_47# VSUBS sky130_fd_pr__nfet_01v8 ad=-0p pd=-0u as=2.8e+09p ps=0u w=420000u l=150000u
X330 sky130_fd_sc_hd__dfrtp_1_7/a_1108_47# sky130_fd_sc_hd__dfrtp_1_7/a_193_47# sky130_fd_sc_hd__dfrtp_1_7/a_761_289# VSUBS sky130_fd_pr__nfet_01v8 ad=0p pd=0u as=0p ps=0u w=360000u l=150000u
X331 sky130_fd_sc_hd__dfrtp_1_7/a_651_413# sky130_fd_sc_hd__inv_2_0/Y VSUBS VSUBS sky130_fd_pr__pfet_01v8_hvt ad=0p pd=0u as=-0p ps=-0u w=420000u l=150000u
X332 sky130_fd_sc_hd__dfrtp_1_7/a_193_47# sky130_fd_sc_hd__dfrtp_1_7/a_27_47# VSUBS VSUBS sky130_fd_pr__nfet_01v8 ad=0p pd=0u as=-0p ps=-0u w=420000u l=150000u
X333 VSUBS sky130_fd_sc_hd__clkbuf_2_1/X sky130_fd_sc_hd__dfrtp_1_7/a_27_47# VSUBS sky130_fd_pr__nfet_01v8 ad=-0p pd=-0u as=0p ps=0u w=420000u l=150000u
X334 VSUBS sky130_fd_sc_hd__clkbuf_2_1/X sky130_fd_sc_hd__dfrtp_1_7/a_27_47# VSUBS sky130_fd_pr__pfet_01v8_hvt ad=-0p pd=-0u as=0p ps=0u w=640000u l=150000u
X335 sky130_fd_sc_hd__buf_4_2/A sky130_fd_sc_hd__dfrtp_1_7/a_1283_21# VSUBS VSUBS sky130_fd_pr__pfet_01v8_hvt ad=0p pd=0u as=-0p ps=-0u w=1e+06u l=150000u
X336 sky130_fd_sc_hd__dfrtp_1_7/a_193_47# sky130_fd_sc_hd__dfrtp_1_7/a_27_47# VSUBS VSUBS sky130_fd_pr__pfet_01v8_hvt ad=0p pd=0u as=-0p ps=-0u w=640000u l=150000u
X337 VSUBS sky130_fd_sc_hd__dfrtp_1_7/a_1108_47# sky130_fd_sc_hd__dfrtp_1_7/a_1283_21# VSUBS sky130_fd_pr__pfet_01v8_hvt ad=-0p pd=-0u as=0p ps=0u w=420000u l=150000u
X338 sky130_fd_sc_hd__dfrtp_1_7/a_1462_47# sky130_fd_sc_hd__inv_2_0/Y VSUBS VSUBS sky130_fd_pr__nfet_01v8 ad=0p pd=0u as=-0p ps=-0u w=420000u l=150000u
X339 sky130_fd_sc_hd__dfrtp_1_7/a_448_47# sky130_fd_sc_hd__xnor2_1_1/Y VSUBS VSUBS sky130_fd_pr__pfet_01v8_hvt ad=0p pd=0u as=-0p ps=-0u w=420000u l=150000u
X340 VSUBS sky130_fd_sc_hd__dfrtp_1_7/a_761_289# sky130_fd_sc_hd__dfrtp_1_7/a_651_413# VSUBS sky130_fd_pr__pfet_01v8_hvt ad=-0p pd=-0u as=0p ps=0u w=420000u l=150000u
X341 sky130_fd_sc_hd__dfrtp_1_7/a_1108_47# sky130_fd_sc_hd__dfrtp_1_7/a_27_47# sky130_fd_sc_hd__dfrtp_1_7/a_761_289# VSUBS sky130_fd_pr__pfet_01v8_hvt ad=0p pd=0u as=0p ps=0u w=420000u l=150000u
X342 sky130_fd_sc_hd__dfrtp_1_7/a_1283_21# sky130_fd_sc_hd__inv_2_0/Y VSUBS VSUBS sky130_fd_pr__pfet_01v8_hvt ad=0p pd=0u as=-0p ps=-0u w=420000u l=150000u
X343 sky130_fd_sc_hd__dfrtp_1_7/a_805_47# sky130_fd_sc_hd__dfrtp_1_7/a_761_289# sky130_fd_sc_hd__dfrtp_1_7/a_639_47# VSUBS sky130_fd_pr__nfet_01v8 ad=0p pd=0u as=0p ps=0u w=420000u l=150000u
X344 VSUBS clk sky130_fd_sc_hd__clkbuf_2_2/a_27_47# VSUBS sky130_fd_pr__pfet_01v8_hvt ad=-0p pd=-0u as=1.73088e+13p ps=0u w=1e+06u l=150000u
X345 VSUBS clk sky130_fd_sc_hd__clkbuf_2_2/a_27_47# VSUBS sky130_fd_pr__nfet_01v8 ad=-0p pd=-0u as=0p ps=0u w=420000u l=150000u
X346 VSUBS sky130_fd_sc_hd__clkbuf_2_2/a_27_47# sky130_fd_sc_hd__clkbuf_2_2/X VSUBS sky130_fd_pr__pfet_01v8_hvt ad=-0p pd=-0u as=1.29e+10p ps=0u w=1e+06u l=150000u
X347 sky130_fd_sc_hd__clkbuf_2_2/X sky130_fd_sc_hd__clkbuf_2_2/a_27_47# VSUBS VSUBS sky130_fd_pr__pfet_01v8_hvt ad=0p pd=0u as=-0p ps=-0u w=1e+06u l=150000u
X348 VSUBS sky130_fd_sc_hd__clkbuf_2_2/a_27_47# sky130_fd_sc_hd__clkbuf_2_2/X VSUBS sky130_fd_pr__nfet_01v8 ad=-0p pd=-0u as=0p ps=0u w=420000u l=150000u
X349 sky130_fd_sc_hd__clkbuf_2_2/X sky130_fd_sc_hd__clkbuf_2_2/a_27_47# VSUBS VSUBS sky130_fd_pr__nfet_01v8 ad=0p pd=0u as=-0p ps=-0u w=420000u l=150000u
X350 VSUBS sky130_fd_sc_hd__buf_4_2/a_27_47# count[5] VSUBS sky130_fd_pr__nfet_01v8 ad=-0p pd=-0u as=4.26986e+16p ps=1.47125e+08u w=650000u l=150000u
X351 count[5] sky130_fd_sc_hd__buf_4_2/a_27_47# VSUBS VSUBS sky130_fd_pr__nfet_01v8 ad=0p pd=0u as=-0p ps=-0u w=650000u l=150000u
X352 VSUBS sky130_fd_sc_hd__buf_4_2/a_27_47# count[5] VSUBS sky130_fd_pr__nfet_01v8 ad=-0p pd=-0u as=0p ps=0u w=650000u l=150000u
X353 count[5] sky130_fd_sc_hd__buf_4_2/a_27_47# VSUBS VSUBS sky130_fd_pr__nfet_01v8 ad=0p pd=0u as=-0p ps=-0u w=650000u l=150000u
X354 VSUBS sky130_fd_sc_hd__buf_4_2/a_27_47# count[5] VSUBS sky130_fd_pr__pfet_01v8_hvt ad=-0p pd=-0u as=0p ps=0u w=1e+06u l=150000u
X355 VSUBS sky130_fd_sc_hd__buf_4_2/A sky130_fd_sc_hd__buf_4_2/a_27_47# VSUBS sky130_fd_pr__nfet_01v8 ad=-0p pd=-0u as=1.67772e+15p ps=0u w=650000u l=150000u
X356 VSUBS sky130_fd_sc_hd__buf_4_2/a_27_47# count[5] VSUBS sky130_fd_pr__pfet_01v8_hvt ad=-0p pd=-0u as=0p ps=0u w=1e+06u l=150000u
X357 VSUBS sky130_fd_sc_hd__buf_4_2/A sky130_fd_sc_hd__buf_4_2/a_27_47# VSUBS sky130_fd_pr__pfet_01v8_hvt ad=-0p pd=-0u as=0p ps=0u w=1e+06u l=150000u
X358 count[5] sky130_fd_sc_hd__buf_4_2/a_27_47# VSUBS VSUBS sky130_fd_pr__pfet_01v8_hvt ad=0p pd=0u as=-0p ps=-0u w=1e+06u l=150000u
X359 count[5] sky130_fd_sc_hd__buf_4_2/a_27_47# VSUBS VSUBS sky130_fd_pr__pfet_01v8_hvt ad=0p pd=0u as=-0p ps=-0u w=1e+06u l=150000u
X360 VSUBS sky130_fd_sc_hd__buf_4_3/a_27_47# count[2] VSUBS sky130_fd_pr__nfet_01v8 ad=-0p pd=-0u as=4.025e+09p ps=0u w=650000u l=150000u
X361 count[2] sky130_fd_sc_hd__buf_4_3/a_27_47# VSUBS VSUBS sky130_fd_pr__nfet_01v8 ad=0p pd=0u as=-0p ps=-0u w=650000u l=150000u
X362 VSUBS sky130_fd_sc_hd__buf_4_3/a_27_47# count[2] VSUBS sky130_fd_pr__nfet_01v8 ad=-0p pd=-0u as=0p ps=0u w=650000u l=150000u
X363 count[2] sky130_fd_sc_hd__buf_4_3/a_27_47# VSUBS VSUBS sky130_fd_pr__nfet_01v8 ad=0p pd=0u as=-0p ps=-0u w=650000u l=150000u
X364 VSUBS sky130_fd_sc_hd__buf_4_3/a_27_47# count[2] VSUBS sky130_fd_pr__pfet_01v8_hvt ad=-0p pd=-0u as=0p ps=0u w=1e+06u l=150000u
X365 VSUBS VSUBS sky130_fd_sc_hd__buf_4_3/a_27_47# VSUBS sky130_fd_pr__nfet_01v8 ad=-0p pd=-0u as=1.67772e+15p ps=0u w=650000u l=150000u
X366 VSUBS sky130_fd_sc_hd__buf_4_3/a_27_47# count[2] VSUBS sky130_fd_pr__pfet_01v8_hvt ad=-0p pd=-0u as=0p ps=0u w=1e+06u l=150000u
X367 VSUBS VSUBS sky130_fd_sc_hd__buf_4_3/a_27_47# VSUBS sky130_fd_pr__pfet_01v8_hvt ad=-0p pd=-0u as=0p ps=0u w=1e+06u l=150000u
X368 count[2] sky130_fd_sc_hd__buf_4_3/a_27_47# VSUBS VSUBS sky130_fd_pr__pfet_01v8_hvt ad=0p pd=0u as=-0p ps=-0u w=1e+06u l=150000u
X369 count[2] sky130_fd_sc_hd__buf_4_3/a_27_47# VSUBS VSUBS sky130_fd_pr__pfet_01v8_hvt ad=0p pd=0u as=-0p ps=-0u w=1e+06u l=150000u
X370 VSUBS sky130_fd_sc_hd__inv_2_0/A sky130_fd_sc_hd__inv_2_0/Y VSUBS sky130_fd_pr__nfet_01v8 ad=-0p pd=-0u as=1.67772e+15p ps=0u w=650000u l=150000u
X371 sky130_fd_sc_hd__inv_2_0/Y sky130_fd_sc_hd__inv_2_0/A VSUBS VSUBS sky130_fd_pr__pfet_01v8_hvt ad=0p pd=0u as=-0p ps=-0u w=1e+06u l=150000u
X372 sky130_fd_sc_hd__inv_2_0/Y sky130_fd_sc_hd__inv_2_0/A VSUBS VSUBS sky130_fd_pr__nfet_01v8 ad=0p pd=0u as=-0p ps=-0u w=650000u l=150000u
X373 VSUBS sky130_fd_sc_hd__inv_2_0/A sky130_fd_sc_hd__inv_2_0/Y VSUBS sky130_fd_pr__pfet_01v8_hvt ad=-0p pd=-0u as=0p ps=0u w=1e+06u l=150000u
X374 sky130_fd_sc_hd__xnor2_1_2/B sky130_fd_sc_hd__ha_1_0/A VSUBS VSUBS sky130_fd_pr__pfet_01v8_hvt ad=0p pd=0u as=-0p ps=-0u w=1e+06u l=150000u
X375 sky130_fd_sc_hd__nand3_1_0/a_193_47# VSUBS sky130_fd_sc_hd__nand3_1_0/a_109_47# VSUBS sky130_fd_pr__nfet_01v8 ad=2e+08p pd=320000u as=2.31497e+16p ps=175000u w=650000u l=150000u
X376 sky130_fd_sc_hd__nand3_1_0/a_109_47# sky130_fd_sc_hd__ha_1_0/B VSUBS VSUBS sky130_fd_pr__nfet_01v8 ad=0p pd=0u as=-0p ps=-0u w=650000u l=150000u
X377 sky130_fd_sc_hd__xnor2_1_2/B sky130_fd_sc_hd__ha_1_0/A sky130_fd_sc_hd__nand3_1_0/a_193_47# VSUBS sky130_fd_pr__nfet_01v8 ad=0p pd=0u as=0p ps=0u w=650000u l=150000u
X378 sky130_fd_sc_hd__xnor2_1_2/B sky130_fd_sc_hd__ha_1_0/B VSUBS VSUBS sky130_fd_pr__pfet_01v8_hvt ad=0p pd=0u as=-0p ps=-0u w=1e+06u l=150000u
X379 VSUBS VSUBS sky130_fd_sc_hd__xnor2_1_2/B VSUBS sky130_fd_pr__pfet_01v8_hvt ad=-0p pd=-0u as=0p ps=0u w=1e+06u l=150000u
X380 sky130_fd_sc_hd__xnor2_1_1/B VSUBS VSUBS VSUBS sky130_fd_pr__pfet_01v8_hvt ad=0p pd=0u as=-0p ps=-0u w=1e+06u l=150000u
X381 sky130_fd_sc_hd__nand3_1_1/a_193_47# sky130_fd_sc_hd__xnor2_1_2/A sky130_fd_sc_hd__nand3_1_1/a_109_47# VSUBS sky130_fd_pr__nfet_01v8 ad=2e+08p pd=0u as=0p ps=0u w=650000u l=150000u
X382 sky130_fd_sc_hd__nand3_1_1/a_109_47# sky130_fd_sc_hd__and3_1_0/X VSUBS VSUBS sky130_fd_pr__nfet_01v8 ad=0p pd=0u as=-0p ps=-0u w=650000u l=150000u
X383 sky130_fd_sc_hd__xnor2_1_1/B VSUBS sky130_fd_sc_hd__nand3_1_1/a_193_47# VSUBS sky130_fd_pr__nfet_01v8 ad=0p pd=0u as=0p ps=0u w=650000u l=150000u
X384 sky130_fd_sc_hd__xnor2_1_1/B sky130_fd_sc_hd__and3_1_0/X VSUBS VSUBS sky130_fd_pr__pfet_01v8_hvt ad=0p pd=0u as=-0p ps=-0u w=1e+06u l=150000u
X385 VSUBS sky130_fd_sc_hd__xnor2_1_2/A sky130_fd_sc_hd__xnor2_1_1/B VSUBS sky130_fd_pr__pfet_01v8_hvt ad=-0p pd=-0u as=0p ps=0u w=1e+06u l=150000u
X386 sky130_fd_sc_hd__nor3_1_0/C VSUBS VSUBS VSUBS sky130_fd_pr__pfet_01v8_hvt ad=1.67771e+15p pd=0u as=-0p ps=-0u w=1e+06u l=150000u
X387 sky130_fd_sc_hd__nand3_1_2/a_193_47# sky130_fd_sc_hd__xnor2_1_2/A sky130_fd_sc_hd__nand3_1_2/a_109_47# VSUBS sky130_fd_pr__nfet_01v8 ad=2.75e+08p pd=0u as=0p ps=0u w=650000u l=150000u
X388 sky130_fd_sc_hd__nand3_1_2/a_109_47# VSUBS VSUBS VSUBS sky130_fd_pr__nfet_01v8 ad=0p pd=0u as=-0p ps=-0u w=650000u l=150000u
X389 sky130_fd_sc_hd__nor3_1_0/C VSUBS sky130_fd_sc_hd__nand3_1_2/a_193_47# VSUBS sky130_fd_pr__nfet_01v8 ad=0p pd=0u as=0p ps=0u w=650000u l=150000u
X390 sky130_fd_sc_hd__nor3_1_0/C VSUBS VSUBS VSUBS sky130_fd_pr__pfet_01v8_hvt ad=0p pd=0u as=-0p ps=-0u w=1e+06u l=150000u
X391 VSUBS sky130_fd_sc_hd__xnor2_1_2/A sky130_fd_sc_hd__nor3_1_0/C VSUBS sky130_fd_pr__pfet_01v8_hvt ad=-0p pd=-0u as=0p ps=0u w=1e+06u l=150000u
X392 sky130_fd_sc_hd__nor2_1_0/A VSUBS VSUBS VSUBS sky130_fd_pr__pfet_01v8_hvt ad=2.425e+09p pd=0u as=-0p ps=-0u w=1e+06u l=150000u
X393 sky130_fd_sc_hd__nand3_1_3/a_193_47# sky130_fd_sc_hd__xor2_1_2/B sky130_fd_sc_hd__nand3_1_3/a_109_47# VSUBS sky130_fd_pr__nfet_01v8 ad=0p pd=0u as=2.75e+08p ps=0u w=650000u l=150000u
X394 sky130_fd_sc_hd__nand3_1_3/a_109_47# sky130_fd_sc_hd__xnor2_1_2/A VSUBS VSUBS sky130_fd_pr__nfet_01v8 ad=0p pd=0u as=-0p ps=-0u w=650000u l=150000u
X395 sky130_fd_sc_hd__nor2_1_0/A VSUBS sky130_fd_sc_hd__nand3_1_3/a_193_47# VSUBS sky130_fd_pr__nfet_01v8 ad=0p pd=0u as=0p ps=0u w=650000u l=150000u
X396 sky130_fd_sc_hd__nor2_1_0/A sky130_fd_sc_hd__xnor2_1_2/A VSUBS VSUBS sky130_fd_pr__pfet_01v8_hvt ad=0p pd=0u as=-0p ps=-0u w=1e+06u l=150000u
X397 VSUBS sky130_fd_sc_hd__xor2_1_2/B sky130_fd_sc_hd__nor2_1_0/A VSUBS sky130_fd_pr__pfet_01v8_hvt ad=-0p pd=-0u as=0p ps=0u w=1e+06u l=150000u
X398 VSUBS sky130_fd_sc_hd__ha_1_0/A sky130_fd_sc_hd__nor3_1_0/A VSUBS sky130_fd_pr__pfet_01v8_hvt ad=-0p pd=-0u as=2.5e+07p ps=5000u w=1e+06u l=150000u
X399 sky130_fd_sc_hd__nor3_1_0/A sky130_fd_sc_hd__ha_1_0/B VSUBS VSUBS sky130_fd_pr__pfet_01v8_hvt ad=0p pd=0u as=-0p ps=-0u w=1e+06u l=150000u
X400 sky130_fd_sc_hd__nand2_1_0/a_113_47# sky130_fd_sc_hd__ha_1_0/B VSUBS VSUBS sky130_fd_pr__nfet_01v8 ad=2.825e+09p pd=0u as=-0p ps=-0u w=650000u l=150000u
X401 sky130_fd_sc_hd__nor3_1_0/A sky130_fd_sc_hd__ha_1_0/A sky130_fd_sc_hd__nand2_1_0/a_113_47# VSUBS sky130_fd_pr__nfet_01v8 ad=0p pd=0u as=0p ps=0u w=650000u l=150000u
X402 VSUBS sky130_fd_sc_hd__buf_4_1/A sky130_fd_sc_hd__nor3_1_0/B VSUBS sky130_fd_pr__pfet_01v8_hvt ad=-0p pd=-0u as=0p ps=0u w=1e+06u l=150000u
X403 sky130_fd_sc_hd__nor3_1_0/B sky130_fd_sc_hd__buf_4_2/A VSUBS VSUBS sky130_fd_pr__pfet_01v8_hvt ad=0p pd=0u as=-0p ps=-0u w=1e+06u l=150000u
X404 sky130_fd_sc_hd__nand2_1_1/a_113_47# sky130_fd_sc_hd__buf_4_2/A VSUBS VSUBS sky130_fd_pr__nfet_01v8 ad=2.425e+09p pd=0u as=-0p ps=-0u w=650000u l=150000u
X405 sky130_fd_sc_hd__nor3_1_0/B sky130_fd_sc_hd__buf_4_1/A sky130_fd_sc_hd__nand2_1_1/a_113_47# VSUBS sky130_fd_pr__nfet_01v8 ad=0p pd=0u as=0p ps=0u w=650000u l=150000u
X406 sky130_fd_sc_hd__clkbuf_1_0/a_75_212# reset VSUBS VSUBS sky130_fd_pr__nfet_01v8 ad=1.5e+08p pd=25000u as=-0p ps=-0u w=520000u l=150000u
X407 VSUBS sky130_fd_sc_hd__clkbuf_1_0/a_75_212# sky130_fd_sc_hd__inv_2_0/A VSUBS sky130_fd_pr__pfet_01v8_hvt ad=-0p pd=-0u as=1.34218e+16p ps=0u w=790000u l=150000u
X408 VSUBS sky130_fd_sc_hd__clkbuf_1_0/a_75_212# sky130_fd_sc_hd__inv_2_0/A VSUBS sky130_fd_pr__nfet_01v8 ad=-0p pd=-0u as=0p ps=0u w=520000u l=150000u
X409 sky130_fd_sc_hd__clkbuf_1_0/a_75_212# reset VSUBS VSUBS sky130_fd_pr__pfet_01v8_hvt ad=0p pd=0u as=-0p ps=-0u w=790000u l=150000u
X410 VSUBS sky130_fd_sc_hd__nor3_1_0/A sky130_fd_sc_hd__xor2_1_0/B VSUBS sky130_fd_pr__nfet_01v8 ad=-0p pd=-0u as=0p ps=0u w=650000u l=150000u
X411 sky130_fd_sc_hd__xor2_1_0/B sky130_fd_sc_hd__nor3_1_0/B VSUBS VSUBS sky130_fd_pr__nfet_01v8 ad=0p pd=0u as=-0p ps=-0u w=650000u l=150000u
X412 VSUBS sky130_fd_sc_hd__nor3_1_0/A sky130_fd_sc_hd__nor3_1_0/a_193_297# VSUBS sky130_fd_pr__pfet_01v8_hvt ad=-0p pd=-0u as=0p ps=0u w=1e+06u l=150000u
X413 VSUBS sky130_fd_sc_hd__nor3_1_0/C sky130_fd_sc_hd__xor2_1_0/B VSUBS sky130_fd_pr__nfet_01v8 ad=-0p pd=-0u as=0p ps=0u w=650000u l=150000u
X414 sky130_fd_sc_hd__nor3_1_0/a_109_297# sky130_fd_sc_hd__nor3_1_0/C sky130_fd_sc_hd__xor2_1_0/B VSUBS sky130_fd_pr__pfet_01v8_hvt ad=5.29667e+16p pd=1.27315e+08u as=0p ps=0u w=1e+06u l=150000u
X415 sky130_fd_sc_hd__nor3_1_0/a_193_297# sky130_fd_sc_hd__nor3_1_0/B sky130_fd_sc_hd__nor3_1_0/a_109_297# VSUBS sky130_fd_pr__pfet_01v8_hvt ad=0p pd=0u as=0p ps=0u w=1e+06u l=150000u
X416 VSUBS sky130_fd_sc_hd__ha_1_0/B sky130_fd_sc_hd__and3_1_0/a_181_47# VSUBS sky130_fd_pr__nfet_01v8 ad=-0p pd=-0u as=1.67772e+15p ps=0u w=420000u l=150000u
X417 VSUBS sky130_fd_sc_hd__ha_1_0/A sky130_fd_sc_hd__and3_1_0/a_27_47# VSUBS sky130_fd_pr__pfet_01v8_hvt ad=-0p pd=-0u as=1.225e+09p ps=0u w=420000u l=150000u
X418 sky130_fd_sc_hd__and3_1_0/a_27_47# sky130_fd_sc_hd__buf_4_1/A VSUBS VSUBS sky130_fd_pr__pfet_01v8_hvt ad=0p pd=0u as=-0p ps=-0u w=420000u l=150000u
X419 sky130_fd_sc_hd__and3_1_0/X sky130_fd_sc_hd__and3_1_0/a_27_47# VSUBS VSUBS sky130_fd_pr__pfet_01v8_hvt ad=1.67703e+15p pd=0u as=-0p ps=-0u w=1e+06u l=150000u
X420 sky130_fd_sc_hd__and3_1_0/a_181_47# sky130_fd_sc_hd__buf_4_1/A sky130_fd_sc_hd__and3_1_0/a_109_47# VSUBS sky130_fd_pr__nfet_01v8 ad=0p pd=0u as=2.425e+09p ps=0u w=420000u l=150000u
X421 sky130_fd_sc_hd__and3_1_0/a_109_47# sky130_fd_sc_hd__ha_1_0/A sky130_fd_sc_hd__and3_1_0/a_27_47# VSUBS sky130_fd_pr__nfet_01v8 ad=0p pd=0u as=0p ps=0u w=420000u l=150000u
X422 sky130_fd_sc_hd__and3_1_0/X sky130_fd_sc_hd__and3_1_0/a_27_47# VSUBS VSUBS sky130_fd_pr__nfet_01v8 ad=0p pd=0u as=-0p ps=-0u w=650000u l=150000u
X423 VSUBS sky130_fd_sc_hd__ha_1_0/B sky130_fd_sc_hd__and3_1_0/a_27_47# VSUBS sky130_fd_pr__pfet_01v8_hvt ad=-0p pd=-0u as=0p ps=0u w=420000u l=150000u
X424 sky130_fd_sc_hd__inv_1_0/Y sky130_fd_sc_hd__ha_1_0/A VSUBS VSUBS sky130_fd_pr__nfet_01v8 ad=1.225e+09p pd=0u as=-0p ps=-0u w=650000u l=150000u
X425 sky130_fd_sc_hd__inv_1_0/Y sky130_fd_sc_hd__ha_1_0/A VSUBS VSUBS sky130_fd_pr__pfet_01v8_hvt ad=0p pd=0u as=-0p ps=-0u w=1e+06u l=150000u
X426 VSUBS sky130_fd_sc_hd__buf_4_0/A sky130_fd_sc_hd__xor2_1_0/a_35_297# VSUBS sky130_fd_pr__nfet_01v8 ad=-0p pd=-0u as=2e+08p ps=0u w=650000u l=150000u
X427 sky130_fd_sc_hd__xor2_1_0/a_35_297# sky130_fd_sc_hd__xor2_1_0/B VSUBS VSUBS sky130_fd_pr__nfet_01v8 ad=0p pd=0u as=-0p ps=-0u w=650000u l=150000u
X428 VSUBS sky130_fd_sc_hd__xor2_1_0/a_35_297# sky130_fd_sc_hd__xor2_1_0/X VSUBS sky130_fd_pr__nfet_01v8 ad=-0p pd=-0u as=0p ps=0u w=650000u l=150000u
X429 VSUBS sky130_fd_sc_hd__xor2_1_0/B sky130_fd_sc_hd__xor2_1_0/a_285_297# VSUBS sky130_fd_pr__pfet_01v8_hvt ad=-0p pd=-0u as=0p ps=0u w=1e+06u l=150000u
X430 sky130_fd_sc_hd__xor2_1_0/a_285_297# sky130_fd_sc_hd__buf_4_0/A VSUBS VSUBS sky130_fd_pr__pfet_01v8_hvt ad=0p pd=0u as=-0p ps=-0u w=1e+06u l=150000u
X431 sky130_fd_sc_hd__xor2_1_0/a_117_297# sky130_fd_sc_hd__xor2_1_0/B sky130_fd_sc_hd__xor2_1_0/a_35_297# VSUBS sky130_fd_pr__pfet_01v8_hvt ad=2.425e+09p pd=0u as=0p ps=0u w=1e+06u l=150000u
X432 VSUBS sky130_fd_sc_hd__buf_4_0/A sky130_fd_sc_hd__xor2_1_0/a_117_297# VSUBS sky130_fd_pr__pfet_01v8_hvt ad=-0p pd=-0u as=0p ps=0u w=1e+06u l=150000u
X433 sky130_fd_sc_hd__xor2_1_0/X sky130_fd_sc_hd__xor2_1_0/B sky130_fd_sc_hd__xor2_1_0/a_285_47# VSUBS sky130_fd_pr__nfet_01v8 ad=0p pd=0u as=2.425e+09p ps=0u w=650000u l=150000u
X434 sky130_fd_sc_hd__xor2_1_0/X sky130_fd_sc_hd__xor2_1_0/a_35_297# sky130_fd_sc_hd__xor2_1_0/a_285_297# VSUBS sky130_fd_pr__pfet_01v8_hvt ad=0p pd=0u as=0p ps=0u w=1e+06u l=150000u
X435 sky130_fd_sc_hd__xor2_1_0/a_285_47# sky130_fd_sc_hd__buf_4_0/A VSUBS VSUBS sky130_fd_pr__nfet_01v8 ad=0p pd=0u as=-0p ps=-0u w=650000u l=150000u
X436 VSUBS VSUBS sky130_fd_sc_hd__xor2_1_1/a_35_297# VSUBS sky130_fd_pr__nfet_01v8 ad=-0p pd=-0u as=1.67772e+15p ps=0u w=650000u l=150000u
X437 sky130_fd_sc_hd__xor2_1_1/a_35_297# sky130_fd_sc_hd__xor2_1_1/B VSUBS VSUBS sky130_fd_pr__nfet_01v8 ad=0p pd=0u as=-0p ps=-0u w=650000u l=150000u
X438 VSUBS sky130_fd_sc_hd__xor2_1_1/a_35_297# sky130_fd_sc_hd__xor2_1_1/X VSUBS sky130_fd_pr__nfet_01v8 ad=-0p pd=-0u as=0p ps=0u w=650000u l=150000u
X439 VSUBS sky130_fd_sc_hd__xor2_1_1/B sky130_fd_sc_hd__xor2_1_1/a_285_297# VSUBS sky130_fd_pr__pfet_01v8_hvt ad=-0p pd=-0u as=0p ps=0u w=1e+06u l=150000u
X440 sky130_fd_sc_hd__xor2_1_1/a_285_297# VSUBS VSUBS VSUBS sky130_fd_pr__pfet_01v8_hvt ad=0p pd=0u as=-0p ps=-0u w=1e+06u l=150000u
X441 sky130_fd_sc_hd__xor2_1_1/a_117_297# sky130_fd_sc_hd__xor2_1_1/B sky130_fd_sc_hd__xor2_1_1/a_35_297# VSUBS sky130_fd_pr__pfet_01v8_hvt ad=0p pd=0u as=0p ps=0u w=1e+06u l=150000u
X442 VSUBS VSUBS sky130_fd_sc_hd__xor2_1_1/a_117_297# VSUBS sky130_fd_pr__pfet_01v8_hvt ad=-0p pd=-0u as=0p ps=0u w=1e+06u l=150000u
X443 sky130_fd_sc_hd__xor2_1_1/X sky130_fd_sc_hd__xor2_1_1/B sky130_fd_sc_hd__xor2_1_1/a_285_47# VSUBS sky130_fd_pr__nfet_01v8 ad=0p pd=0u as=7.16211e+14p ps=0u w=650000u l=150000u
X444 sky130_fd_sc_hd__xor2_1_1/X sky130_fd_sc_hd__xor2_1_1/a_35_297# sky130_fd_sc_hd__xor2_1_1/a_285_297# VSUBS sky130_fd_pr__pfet_01v8_hvt ad=0p pd=0u as=0p ps=0u w=1e+06u l=150000u
X445 sky130_fd_sc_hd__xor2_1_1/a_285_47# VSUBS VSUBS VSUBS sky130_fd_pr__nfet_01v8 ad=0p pd=0u as=-0p ps=-0u w=650000u l=150000u
X446 VSUBS VSUBS sky130_fd_sc_hd__xor2_1_2/a_35_297# VSUBS sky130_fd_pr__nfet_01v8 ad=-0p pd=-0u as=1.6386e+12p ps=0u w=650000u l=150000u
X447 sky130_fd_sc_hd__xor2_1_2/a_35_297# sky130_fd_sc_hd__xor2_1_2/B VSUBS VSUBS sky130_fd_pr__nfet_01v8 ad=0p pd=0u as=-0p ps=-0u w=650000u l=150000u
X448 VSUBS sky130_fd_sc_hd__xor2_1_2/a_35_297# sky130_fd_sc_hd__xor2_1_2/X VSUBS sky130_fd_pr__nfet_01v8 ad=-0p pd=-0u as=1.67771e+15p ps=0u w=650000u l=150000u
X449 VSUBS sky130_fd_sc_hd__xor2_1_2/B sky130_fd_sc_hd__xor2_1_2/a_285_297# VSUBS sky130_fd_pr__pfet_01v8_hvt ad=-0p pd=-0u as=0p ps=0u w=1e+06u l=150000u
X450 sky130_fd_sc_hd__xor2_1_2/a_285_297# VSUBS VSUBS VSUBS sky130_fd_pr__pfet_01v8_hvt ad=0p pd=0u as=-0p ps=-0u w=1e+06u l=150000u
X451 sky130_fd_sc_hd__xor2_1_2/a_117_297# sky130_fd_sc_hd__xor2_1_2/B sky130_fd_sc_hd__xor2_1_2/a_35_297# VSUBS sky130_fd_pr__pfet_01v8_hvt ad=2.425e+09p pd=0u as=0p ps=0u w=1e+06u l=150000u
X452 VSUBS VSUBS sky130_fd_sc_hd__xor2_1_2/a_117_297# VSUBS sky130_fd_pr__pfet_01v8_hvt ad=-0p pd=-0u as=0p ps=0u w=1e+06u l=150000u
X453 sky130_fd_sc_hd__xor2_1_2/X sky130_fd_sc_hd__xor2_1_2/B sky130_fd_sc_hd__xor2_1_2/a_285_47# VSUBS sky130_fd_pr__nfet_01v8 ad=0p pd=0u as=2.425e+09p ps=0u w=650000u l=150000u
X454 sky130_fd_sc_hd__xor2_1_2/X sky130_fd_sc_hd__xor2_1_2/a_35_297# sky130_fd_sc_hd__xor2_1_2/a_285_297# VSUBS sky130_fd_pr__pfet_01v8_hvt ad=0p pd=0u as=0p ps=0u w=1e+06u l=150000u
X455 sky130_fd_sc_hd__xor2_1_2/a_285_47# VSUBS VSUBS VSUBS sky130_fd_pr__nfet_01v8 ad=0p pd=0u as=-0p ps=-0u w=650000u l=150000u
