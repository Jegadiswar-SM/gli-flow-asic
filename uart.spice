* SPICE3 file created from uart.ext - technology: minimum

.option scale=1u
